placed br_ic sel=0
.param sel=0
v1 a 0 0
r1 a c 1k
c1 c 0 1u
.if (sel==1)
.ic v(c)=0.7
.endif
.tran 1u 2u uic
.print tran v(c)
.end
