placed br_control sel=0
.param sel=0
v1 a 0 dc 1
r1 a b 1k
r2 b 0 1k
d1 b 0 dm
.model dm d is=1e-14
.if (sel==1)
.control
echo CONTROL_IN_BRANCH
.endc
.endif
.control
op
print v(b)
.endc
.end
