placed br_func sel=1
.param sel=1
v1 a 0 1
r1 a b 1k
r2 b 0 {fx(1k)}
.if (sel==1)
.func fx(x)=x*2
.else
.func fx(x)=x*4
.endif
.control
op
print v(b)
.endc
.end
