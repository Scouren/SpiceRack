vdmos body diode vj=1 cjo=1n, off, drain 5 V, AC 1 MHz
.model mn vdmos kp=20 vto=2 cjo=1n vj=1 fc=0.5
vd d 0 dc 5 ac 1
vg g 0 0
m1 d g 0 mn
.options reltol=1e-9
.control
set numdgt=12
ac lin 1 1meg 1meg
print mag(i(vd))
.endc
.end
