diode_noisr off (80 C, m=3), bkdn (vds=-5.2), acd
.model nm d is=1e-14 n=1.05 rs=5 bv=5 ibv=1e-6 ikf=10m cjo=1p vj=0.7 m=0.4 fc=0.5 tt=1n xti=3 eg=1.11
vd d 0 dc -5.2 ac 1
d1 d 0 nm area=2 m=3
.temp 80
.options reltol=1e-9 abstol=1e-15
.control
set numdgt=12
ac lin 1 1g 1g
print mag(i(vd))
.endc
.end
