mos6_nocap m3 (27 C, m=3), lin (vgs=3.0, vds=0.2, vbs=-0.5), acg
.model nm nmos level=6 vto=0.7 kv=2 nv=0.8 kc=5e-5 nc=1.2 lambda0=0.02 lambda1=0.01 gamma=0.5 gamma1=0.1 sigma=0.01 phi=0.7
vd d 0 dc 0.2
vg g 0 dc 3.0 ac 1
vb b 0 dc -0.5
m1 d g 0 b nm w=10u l=2u ad=20p as=20p pd=24u ps=24u m=3
.temp 27
.options reltol=1e-9 abstol=1e-15
.control
set numdgt=12
ac lin 1 1g 1g
print mag(i(vd))
.endc
.end
