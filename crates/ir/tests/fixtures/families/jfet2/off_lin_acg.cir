jfet2 off (80 C, m=3), lin (vgs=0.0, vds=0.2), acg
.model nm njf level=2 vt0=-2 beta=1e-4 lambda=0.02 rd=10 rs=10 cgs=2p cgd=1p is=1e-14 n=1 fc=0.5 delta=0.1 xi=1000 p=2 q=2 z=1 vbi=1 hfeta=0.05
vd d 0 dc 0.2
vg g 0 dc 0.0 ac 1
j1 d g 0 nm area=2 m=3
.temp 80
.options reltol=1e-9 abstol=1e-15
.control
set numdgt=12
ac lin 1 1g 1g
print mag(i(vd))
.endc
.end
