dc_full_0.5
.model d d rs=1.0 is=1e-9 tt=1e-6 cjo=50n bv=5 ibv=1e-6
v1 1 0 dc 0.5
d1 1 0 d
.options reltol=1e-9 abstol=1e-15 vntol=1e-12
.control
set numdgt=12
op
print i(v1)
.endc
.end
