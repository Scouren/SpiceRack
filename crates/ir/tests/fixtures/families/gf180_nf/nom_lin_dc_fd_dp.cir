gf180_nf nom (27 C, m=1), lin (vgs=3.3, vds=0.1, vbs=-0.5), dc
.include "../kit/gf180mcuD/libs.tech/ngspice/design.ngspice"
.lib "../kit/gf180mcuD/libs.tech/ngspice/sm141064.ngspice" typical
vd d 0 dc 0.10001
vg g 0 dc 3.3
vb b 0 dc -0.5
x1 d g 0 b nfet_03v3 w=10u l=0.5u nf=3
.temp 27
.options reltol=1e-9 abstol=1e-15
.control
set numdgt=12
op
print i(vd)
.endc
.end
