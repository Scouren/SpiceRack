mes1 off (80 C, m=3), cut (vgs=-1.5, vds=2.0), dc
.model nm nmf level=1 vt0=-1 alpha=2 beta=2.5e-3 lambda=0.05 b=0.3 rd=5 rs=5 cgs=1p cgd=0.5p pb=0.8 is=1e-14 fc=0.5
vd d 0 dc 2.0
vg g 0 dc -1.5
z1 d g 0 nm area=2 m=3
.temp 80
.options reltol=1e-9 abstol=1e-15
.control
set numdgt=12
op
print i(vd)
.endc
.end
