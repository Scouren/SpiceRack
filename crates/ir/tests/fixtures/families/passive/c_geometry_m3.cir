passive c_geometry m3 (27 C, m=3), ac (1 V on a, 1 MHz)
.model cm c cj=1e-3 cjsw=1e-9 narrow=0.1u short=0.2u tc1=1e-3 tc2=1e-5
vd a 0 dc 1 ac 1
c1 a 0 cm w=10u l=20u m=3
.temp 27
.options reltol=1e-9 abstol=1e-15
.control
set numdgt=12
ac lin 1 1meg 1meg
print mag(i(vd))
.endc
.end
