passive c_value off (80 C, m=3), ac (1 V on a, 1 MHz)
vd a 0 dc 1 ac 1
c1 a 0 1p tc1=1e-3 tc2=1e-5 m=3
.temp 80
.options reltol=1e-9 abstol=1e-15
.control
set numdgt=12
ac lin 1 1meg 1meg
print mag(i(vd))
.endc
.end
