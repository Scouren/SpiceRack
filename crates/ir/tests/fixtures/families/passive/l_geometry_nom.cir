passive l_geometry nom (27 C, m=1), ac (1 V on a, 1 MHz)
.model lm l csect=1e-6 length=1e-3 mu=100 tc1=1e-3 tc2=1e-5
rs a b 1
vd a 0 dc 1 ac 1
l1 b 0 lm nt=10
.temp 27
.options reltol=1e-9 abstol=1e-15
.control
set numdgt=12
ac lin 1 1meg 1meg
print mag(i(vd))
.endc
.end
