bjt transient, 80 C, m=3, pulse 0..5 V on the gate through 10k, 2k load from 3 V
.model nm npn ibe=1e-16 ibc=2e-16 bf=100 br=2 nf=1 nr=1 vaf=50 var=20 ikf=10m ikr=5m ise=1e-14 ne=1.5 isc=1e-14 nc=2 rb=50 rbm=10 irb=1m rc=5 re=1 cje=1p vje=0.75 mje=0.33 cjc=0.5p vjc=0.75 mjc=0.33 xcjc=0.8 cjs=0.3p vjs=0.7 mjs=0.5 tf=10p xtf=1 vtf=2 itf=10m tr=1n xtb=1.5 eg=1.11 xti=3 subs=1
vdd dd 0 dc 3
rl dd d 2k
vin in 0 dc 0 pulse(0 5 1n 1n 1n 5n 20n)
rg in g 10k
vb b 0 dc -0.5
q1 d g 0 b nm area=2 m=3
.temp 80
.options reltol=1e-6 abstol=1e-15
.control
set numdgt=12
tran 10p 40n 0 20p
meas tran t2n find v(d) at=2n
meas tran t3n find v(d) at=3n
meas tran t4n find v(d) at=4n
meas tran t6n find v(d) at=6n
meas tran t8n find v(d) at=8n
meas tran t9n find v(d) at=9n
meas tran t12n find v(d) at=12n
meas tran t20n find v(d) at=20n
meas tran t30n find v(d) at=30n
.endc
.end
