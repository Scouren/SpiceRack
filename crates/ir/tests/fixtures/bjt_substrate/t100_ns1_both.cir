substrate saturation current: iss=1e-12 ns=1 ibe=1e-15 ibc=1e-15 at 100 C (vertical, substrate forward 0.6 V)
.model qm npn is=1e-15 bf=100 iss=1e-12 ns=1 subs=1 ibe=1e-15 ibc=1e-15
vc c 0 0
vb b 0 0
ve e 0 0
vs s 0 0.6
q1 c b e s qm
.temp 100
.options reltol=1e-9
.control
op
print i(vs)
.endc
.end
