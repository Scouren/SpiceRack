// t

simulator lang=spectre

v1 (a 0) vsource dc=0 type=pwl wave=[0 0 1m 1 r 0 td 500u]
r1 (a 0) resistor r=1k

tran1 tran step=9.999999999999999e-6 stop=2.2500000000000004m
