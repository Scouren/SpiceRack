// t

simulator lang=spectre

model resbody resistor tc1=1m tnom=25 l=10u w=10u r=1m af=1 wdexp=0 ldexp=0 leexp=1 weexp=1

i1 (0 a) isource dc=1m
rb (a 0) resistor r=1k*(1+0.1*abs(v(a)))
mytemp options temp=60

op1 dc
