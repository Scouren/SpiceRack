// t

simulator lang=spectre

parameters wr=2u
model rpoly resistor rsh=100 etch=100n etchl=200n tc1=1m tc2=2u tnom=25 l=10u w=10u af=1 wdexp=0 ldexp=0 leexp=1 weexp=1
model rvia resistor r=50 tc1=2m l=10u w=10u af=1 wdexp=0 ldexp=0 leexp=1 weexp=1
model rnone resistor l=10u w=10u r=1m af=1 wdexp=0 ldexp=0 leexp=1 weexp=1
model rdef resistor rsh=10 l=10u w=10u af=1 wdexp=0 ldexp=0 leexp=1 weexp=1

i1 (0 a1) isource dc=1m
r1 (a1 0) rpoly w=wr l=10u
i2 (0 a2) isource dc=1m
r2 (a2 0) rvia trise=10
i3 (0 a3) isource dc=1m
r3 (a3 0) rnone
i4 (0 a4) isource dc=1m
r4 (a4 0) resistor r=1k m=(4)/(2)
i5 (0 a5) isource dc=1m
r5 (a5 0) rdef
i6 (0 a6) isource dc=1m
r6 (a6 0) rpoly l=20u
mytemp options temp=60

op1 dc
