// A made-up Verilog-A varactor: no real PDK data.
`include "disciplines.vams"
module varactor_va(inout electrical p, inout electrical n);
  (* desc="junction area" *) parameter real area = 1e-12 from (0:inf);
  parameter real c0 = 1e-15, vbi = 0.7 from (0:inf);
  localparam real two = 2.0;
  analog I(p, n) <+ ddt(c0 * area / 1e-12 * V(p, n) / vbi);
endmodule
