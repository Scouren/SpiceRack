tran_exp: the transient of an RC low-pass (tau 10 ns) under an EXP source
v1 in 0 dc 0 exp(0 1 5n 5n 40n 10n)
r1 in out 1k
c1 out 0 10p
.tran 0.5n 100n
.end
