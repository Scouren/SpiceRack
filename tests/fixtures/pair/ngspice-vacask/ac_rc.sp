ac_rc: the AC sweep of an RC low-pass (pole at 1/(2 pi 1k 1n) = 159 kHz), 10 points a decade
v1 in 0 dc 0 ac 1
r1 in out 1k
c1 out 0 1n
.ac dec 10 1k 100meg
.end
