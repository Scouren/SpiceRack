dc_sweep: a DC sweep of the source of a divider, 0 to 5 V by 0.25 V
v1 in 0 dc 0
r1 in out 1k
r2 out 0 3k
.dc v1 0 5 0.25
.end
