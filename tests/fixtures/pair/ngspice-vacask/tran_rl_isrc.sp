tran_rl_isrc: a PULSE current source into a parallel RL (tau L/R = 10 ns) and an inductor current
i1 0 a dc 0 pulse(0 1m 2n 1n 1n 30n 60n)
r1 a 0 1k
l1 a 0 10u
.tran 0.2n 60n
.end
