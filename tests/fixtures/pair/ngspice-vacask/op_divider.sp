op_divider: the operating point of a resistor divider under a DC source (out = 5 * 2k/3k)
v1 in 0 dc 5
r1 in out 1k
r2 out 0 2k
.op
.end
