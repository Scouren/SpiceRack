tran_uic: a capacitor with an initial condition discharging through a resistor, under UIC
r1 a 0 1k
c1 a 0 1n ic=2
.tran 10n 5u uic
.end
