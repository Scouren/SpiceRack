controlled: the four linear controlled sources (E, G, F, H) at an operating point
v1 in 0 dc 1
r1 in 0 1k
e1 e 0 in 0 2
re e 0 1k
g1 0 g in 0 1m
rg g 0 1k
vsense in s dc 0
rs s 0 1k
f1 0 f vsense 3
rf f 0 1k
h1 h 0 vsense 500
rh h 0 1k
.op
.end
