tran_rc_pulse: the transient of an RC low-pass (tau 1 ns) under a PULSE source
v1 in 0 dc 0 pulse(0 1 1n 1n 1n 5n 20n)
r1 in out 1k
c1 out 0 1p
.tran 0.1n 40n
.end
