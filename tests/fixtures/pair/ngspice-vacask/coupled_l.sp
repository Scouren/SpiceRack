coupled_l: two coupled inductors (k = 0.9), a transformer driven by a SIN, loaded by a resistor
v1 in 0 dc 0 sin(0 1 1meg)
r1 in a 10
l1 a 0 10u
l2 b 0 40u
k1 l1 l2 0.9
r2 b 0 1k
.tran 5n 4u
.end
