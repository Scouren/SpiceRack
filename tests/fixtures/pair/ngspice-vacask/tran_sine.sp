tran_sine: the transient of an RC low-pass (tau 100 ns) under a SIN source of 1 MHz with an offset
v1 in 0 dc 0 sin(0.5 1 1meg)
r1 in out 1k
c1 out 0 100p
.tran 10n 5u
.end
