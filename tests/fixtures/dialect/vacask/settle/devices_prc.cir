R C L reference (ngspice-45) for devices_prc.sim
i1 0 n1 dc 1m ac 1
r1 n1 0 1k tc1=0.01 tc2=0.001
i2 0 n2 dc 1m ac 1
r2 n2 0 1k tce=1
i3 0 n3 dc 1m ac 1
r3 n3 0 1k temp=77 tc1=0.01
i4 0 n4 dc 1m ac 1
r4 n4 0 1k dtemp=10 tc1=0.01
i5 0 n5 dc 1m ac 1
r5 n5 0 1k scale=2
i6 0 n6 dc 1m ac 1
r6 n6 0 1k m=2
i7 0 c1 ac 1
rc1 c1 0 1e12
c1 c1 0 1n tc1=0.01 tc2=0.001 m=2
i8 0 c2 ac 1
rc2 c2 0 1e12
c2 c2 0 1n dtemp=10 tc1=0.01 scale=3
i9 0 l1 ac 1
l1 l1 0 1m tc1=0.01 tc2=0.001 m=2
i10 0 l2 ac 1
l2 l2 0 1m temp=77 tc1=0.01 scale=3
.options tnom=27 temp=50 reltol=1e-9
.control

ac lin 1 1k 1k
print mag(v(n1)) mag(v(n2)) mag(v(n3)) mag(v(n4)) mag(v(n5)) mag(v(n6)) mag(v(c1)) mag(v(c2)) mag(v(l1)) mag(v(l2))
.endc
.end
