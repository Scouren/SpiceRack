grid_numparam
* settle grid: values in the raw file (ngspice -b -r), compared with the IR's reference evaluator by tests/dialect_ngspice_grid.rs
vg0 g0 0 {abs(-3)}
vg1 g1 0 {abs(-2.5)}
vg2 g2 0 {abs(-1.5)}
vg3 g3 0 {abs(-1)}
vg4 g4 0 {abs(-0.5)}
vg5 g5 0 {abs(-1e-07)}
vg6 g6 0 {abs(0)}
vg7 g7 0 {abs(1e-07)}
vg8 g8 0 {abs(0.5)}
vg9 g9 0 {abs(1)}
vg10 g10 0 {abs(1.5)}
vg11 g11 0 {abs(2.5)}
vg12 g12 0 {abs(3)}
vg13 g13 0 {abs(-1000.0)}
vg14 g14 0 {abs(1000.0)}
vg15 g15 0 {sqrt(0)}
vg16 g16 0 {sqrt(1e-07)}
vg17 g17 0 {sqrt(0.5)}
vg18 g18 0 {sqrt(1)}
vg19 g19 0 {sqrt(1.5)}
vg20 g20 0 {sqrt(2.5)}
vg21 g21 0 {sqrt(3)}
vg22 g22 0 {sqrt(1000.0)}
vg23 g23 0 {exp(-3)}
vg24 g24 0 {exp(-2.5)}
vg25 g25 0 {exp(-1.5)}
vg26 g26 0 {exp(-1)}
vg27 g27 0 {exp(-0.5)}
vg28 g28 0 {exp(-1e-07)}
vg29 g29 0 {exp(0)}
vg30 g30 0 {exp(1e-07)}
vg31 g31 0 {exp(0.5)}
vg32 g32 0 {exp(1)}
vg33 g33 0 {exp(1.5)}
vg34 g34 0 {exp(2.5)}
vg35 g35 0 {exp(3)}
vg36 g36 0 {exp(-30)}
vg37 g37 0 {exp(30)}
vg38 g38 0 {exp(-50)}
vg39 g39 0 {exp(50)}
vg40 g40 0 {exp(-250)}
vg41 g41 0 {exp(250)}
vg42 g42 0 {ln(1e-07)}
vg43 g43 0 {ln(0.5)}
vg44 g44 0 {ln(1)}
vg45 g45 0 {ln(1.5)}
vg46 g46 0 {ln(2.5)}
vg47 g47 0 {ln(3)}
vg48 g48 0 {ln(1000.0)}
vg49 g49 0 {log(1e-07)}
vg50 g50 0 {log(0.5)}
vg51 g51 0 {log(1)}
vg52 g52 0 {log(1.5)}
vg53 g53 0 {log(2.5)}
vg54 g54 0 {log(3)}
vg55 g55 0 {log(1000.0)}
vg56 g56 0 {log10(1e-07)}
vg57 g57 0 {log10(0.5)}
vg58 g58 0 {log10(1)}
vg59 g59 0 {log10(1.5)}
vg60 g60 0 {log10(2.5)}
vg61 g61 0 {log10(3)}
vg62 g62 0 {log10(1000.0)}
vg63 g63 0 {sin(-3)}
vg64 g64 0 {sin(-2.5)}
vg65 g65 0 {sin(-1.5)}
vg66 g66 0 {sin(-1)}
vg67 g67 0 {sin(-0.5)}
vg68 g68 0 {sin(-1e-07)}
vg69 g69 0 {sin(0)}
vg70 g70 0 {sin(1e-07)}
vg71 g71 0 {sin(0.5)}
vg72 g72 0 {sin(1)}
vg73 g73 0 {sin(1.5)}
vg74 g74 0 {sin(2.5)}
vg75 g75 0 {sin(3)}
vg76 g76 0 {sin(-1000.0)}
vg77 g77 0 {sin(1000.0)}
vg78 g78 0 {cos(-3)}
vg79 g79 0 {cos(-2.5)}
vg80 g80 0 {cos(-1.5)}
vg81 g81 0 {cos(-1)}
vg82 g82 0 {cos(-0.5)}
vg83 g83 0 {cos(-1e-07)}
vg84 g84 0 {cos(0)}
vg85 g85 0 {cos(1e-07)}
vg86 g86 0 {cos(0.5)}
vg87 g87 0 {cos(1)}
vg88 g88 0 {cos(1.5)}
vg89 g89 0 {cos(2.5)}
vg90 g90 0 {cos(3)}
vg91 g91 0 {cos(-1000.0)}
vg92 g92 0 {cos(1000.0)}
vg93 g93 0 {tan(-3)}
vg94 g94 0 {tan(-2.5)}
vg95 g95 0 {tan(-1.5)}
vg96 g96 0 {tan(-1)}
vg97 g97 0 {tan(-0.5)}
vg98 g98 0 {tan(-1e-07)}
vg99 g99 0 {tan(0)}
vg100 g100 0 {tan(1e-07)}
vg101 g101 0 {tan(0.5)}
vg102 g102 0 {tan(1)}
vg103 g103 0 {tan(1.5)}
vg104 g104 0 {tan(2.5)}
vg105 g105 0 {tan(3)}
vg106 g106 0 {tan(-1000.0)}
vg107 g107 0 {tan(1000.0)}
vg108 g108 0 {asin(-1)}
vg109 g109 0 {asin(-0.99)}
vg110 g110 0 {asin(-0.5)}
vg111 g111 0 {asin(-1e-07)}
vg112 g112 0 {asin(0)}
vg113 g113 0 {asin(1e-07)}
vg114 g114 0 {asin(0.5)}
vg115 g115 0 {asin(0.99)}
vg116 g116 0 {asin(1)}
vg117 g117 0 {acos(-1)}
vg118 g118 0 {acos(-0.99)}
vg119 g119 0 {acos(-0.5)}
vg120 g120 0 {acos(-1e-07)}
vg121 g121 0 {acos(0)}
vg122 g122 0 {acos(1e-07)}
vg123 g123 0 {acos(0.5)}
vg124 g124 0 {acos(0.99)}
vg125 g125 0 {acos(1)}
vg126 g126 0 {atan(-3)}
vg127 g127 0 {atan(-2.5)}
vg128 g128 0 {atan(-1.5)}
vg129 g129 0 {atan(-1)}
vg130 g130 0 {atan(-0.5)}
vg131 g131 0 {atan(-1e-07)}
vg132 g132 0 {atan(0)}
vg133 g133 0 {atan(1e-07)}
vg134 g134 0 {atan(0.5)}
vg135 g135 0 {atan(1)}
vg136 g136 0 {atan(1.5)}
vg137 g137 0 {atan(2.5)}
vg138 g138 0 {atan(3)}
vg139 g139 0 {atan(-1000.0)}
vg140 g140 0 {atan(1000.0)}
vg141 g141 0 {arctan(-3)}
vg142 g142 0 {arctan(-2.5)}
vg143 g143 0 {arctan(-1.5)}
vg144 g144 0 {arctan(-1)}
vg145 g145 0 {arctan(-0.5)}
vg146 g146 0 {arctan(-1e-07)}
vg147 g147 0 {arctan(0)}
vg148 g148 0 {arctan(1e-07)}
vg149 g149 0 {arctan(0.5)}
vg150 g150 0 {arctan(1)}
vg151 g151 0 {arctan(1.5)}
vg152 g152 0 {arctan(2.5)}
vg153 g153 0 {arctan(3)}
vg154 g154 0 {arctan(-1000.0)}
vg155 g155 0 {arctan(1000.0)}
vg156 g156 0 {sinh(-3)}
vg157 g157 0 {sinh(-2.5)}
vg158 g158 0 {sinh(-1.5)}
vg159 g159 0 {sinh(-1)}
vg160 g160 0 {sinh(-0.5)}
vg161 g161 0 {sinh(-1e-07)}
vg162 g162 0 {sinh(0)}
vg163 g163 0 {sinh(1e-07)}
vg164 g164 0 {sinh(0.5)}
vg165 g165 0 {sinh(1)}
vg166 g166 0 {sinh(1.5)}
vg167 g167 0 {sinh(2.5)}
vg168 g168 0 {sinh(3)}
vg169 g169 0 {sinh(-30)}
vg170 g170 0 {sinh(30)}
vg171 g171 0 {cosh(-3)}
vg172 g172 0 {cosh(-2.5)}
vg173 g173 0 {cosh(-1.5)}
vg174 g174 0 {cosh(-1)}
vg175 g175 0 {cosh(-0.5)}
vg176 g176 0 {cosh(-1e-07)}
vg177 g177 0 {cosh(0)}
vg178 g178 0 {cosh(1e-07)}
vg179 g179 0 {cosh(0.5)}
vg180 g180 0 {cosh(1)}
vg181 g181 0 {cosh(1.5)}
vg182 g182 0 {cosh(2.5)}
vg183 g183 0 {cosh(3)}
vg184 g184 0 {cosh(-30)}
vg185 g185 0 {cosh(30)}
vg186 g186 0 {tanh(-3)}
vg187 g187 0 {tanh(-2.5)}
vg188 g188 0 {tanh(-1.5)}
vg189 g189 0 {tanh(-1)}
vg190 g190 0 {tanh(-0.5)}
vg191 g191 0 {tanh(-1e-07)}
vg192 g192 0 {tanh(0)}
vg193 g193 0 {tanh(1e-07)}
vg194 g194 0 {tanh(0.5)}
vg195 g195 0 {tanh(1)}
vg196 g196 0 {tanh(1.5)}
vg197 g197 0 {tanh(2.5)}
vg198 g198 0 {tanh(3)}
vg199 g199 0 {tanh(-1000.0)}
vg200 g200 0 {tanh(1000.0)}
vg201 g201 0 {asinh(-3)}
vg202 g202 0 {asinh(-2.5)}
vg203 g203 0 {asinh(-1.5)}
vg204 g204 0 {asinh(-1)}
vg205 g205 0 {asinh(-0.5)}
vg206 g206 0 {asinh(-1e-07)}
vg207 g207 0 {asinh(0)}
vg208 g208 0 {asinh(1e-07)}
vg209 g209 0 {asinh(0.5)}
vg210 g210 0 {asinh(1)}
vg211 g211 0 {asinh(1.5)}
vg212 g212 0 {asinh(2.5)}
vg213 g213 0 {asinh(3)}
vg214 g214 0 {asinh(-1000.0)}
vg215 g215 0 {asinh(1000.0)}
vg216 g216 0 {acosh(1)}
vg217 g217 0 {acosh(1.5)}
vg218 g218 0 {acosh(2.5)}
vg219 g219 0 {acosh(3)}
vg220 g220 0 {acosh(1000.0)}
vg221 g221 0 {atanh(-0.99)}
vg222 g222 0 {atanh(-0.5)}
vg223 g223 0 {atanh(-1e-07)}
vg224 g224 0 {atanh(0)}
vg225 g225 0 {atanh(1e-07)}
vg226 g226 0 {atanh(0.5)}
vg227 g227 0 {atanh(0.99)}
vg228 g228 0 {pow(-2.5, -2)}
vg229 g229 0 {pow(-2.5, -1)}
vg230 g230 0 {pow(-2.5, 0)}
vg231 g231 0 {pow(-2.5, 1)}
vg232 g232 0 {pow(-2.5, 2)}
vg233 g233 0 {pow(-2.5, 3)}
vg234 g234 0 {pow(-1, -2)}
vg235 g235 0 {pow(-1, -1)}
vg236 g236 0 {pow(-1, 0)}
vg237 g237 0 {pow(-1, 1)}
vg238 g238 0 {pow(-1, 2)}
vg239 g239 0 {pow(-1, 3)}
vg240 g240 0 {pow(-0.5, -2)}
vg241 g241 0 {pow(-0.5, -1)}
vg242 g242 0 {pow(-0.5, 0)}
vg243 g243 0 {pow(-0.5, 1)}
vg244 g244 0 {pow(-0.5, 2)}
vg245 g245 0 {pow(-0.5, 3)}
vg246 g246 0 {pow(0, 0)}
vg247 g247 0 {pow(0, 0.5)}
vg248 g248 0 {pow(0, 1)}
vg249 g249 0 {pow(0, 2)}
vg250 g250 0 {pow(0, 3)}
vg251 g251 0 {pow(0.5, -2)}
vg252 g252 0 {pow(0.5, -1)}
vg253 g253 0 {pow(0.5, -0.5)}
vg254 g254 0 {pow(0.5, 0)}
vg255 g255 0 {pow(0.5, 0.5)}
vg256 g256 0 {pow(0.5, 1)}
vg257 g257 0 {pow(0.5, 2)}
vg258 g258 0 {pow(0.5, 3)}
vg259 g259 0 {pow(1, -2)}
vg260 g260 0 {pow(1, -1)}
vg261 g261 0 {pow(1, -0.5)}
vg262 g262 0 {pow(1, 0)}
vg263 g263 0 {pow(1, 0.5)}
vg264 g264 0 {pow(1, 1)}
vg265 g265 0 {pow(1, 2)}
vg266 g266 0 {pow(1, 3)}
vg267 g267 0 {pow(2.5, -2)}
vg268 g268 0 {pow(2.5, -1)}
vg269 g269 0 {pow(2.5, -0.5)}
vg270 g270 0 {pow(2.5, 0)}
vg271 g271 0 {pow(2.5, 0.5)}
vg272 g272 0 {pow(2.5, 1)}
vg273 g273 0 {pow(2.5, 2)}
vg274 g274 0 {pow(2.5, 3)}
vg275 g275 0 {pwr(-2.5, -2)}
vg276 g276 0 {pwr(-2.5, -1)}
vg277 g277 0 {pwr(-2.5, -0.5)}
vg278 g278 0 {pwr(-2.5, 0)}
vg279 g279 0 {pwr(-2.5, 0.5)}
vg280 g280 0 {pwr(-2.5, 1)}
vg281 g281 0 {pwr(-2.5, 2)}
vg282 g282 0 {pwr(-2.5, 3)}
vg283 g283 0 {pwr(-1, -2)}
vg284 g284 0 {pwr(-1, -1)}
vg285 g285 0 {pwr(-1, -0.5)}
vg286 g286 0 {pwr(-1, 0)}
vg287 g287 0 {pwr(-1, 0.5)}
vg288 g288 0 {pwr(-1, 1)}
vg289 g289 0 {pwr(-1, 2)}
vg290 g290 0 {pwr(-1, 3)}
vg291 g291 0 {pwr(-0.5, -2)}
vg292 g292 0 {pwr(-0.5, -1)}
vg293 g293 0 {pwr(-0.5, -0.5)}
vg294 g294 0 {pwr(-0.5, 0)}
vg295 g295 0 {pwr(-0.5, 0.5)}
vg296 g296 0 {pwr(-0.5, 1)}
vg297 g297 0 {pwr(-0.5, 2)}
vg298 g298 0 {pwr(-0.5, 3)}
vg299 g299 0 {pwr(0, 0)}
vg300 g300 0 {pwr(0, 0.5)}
vg301 g301 0 {pwr(0, 1)}
vg302 g302 0 {pwr(0, 2)}
vg303 g303 0 {pwr(0, 3)}
vg304 g304 0 {pwr(0.5, -2)}
vg305 g305 0 {pwr(0.5, -1)}
vg306 g306 0 {pwr(0.5, -0.5)}
vg307 g307 0 {pwr(0.5, 0)}
vg308 g308 0 {pwr(0.5, 0.5)}
vg309 g309 0 {pwr(0.5, 1)}
vg310 g310 0 {pwr(0.5, 2)}
vg311 g311 0 {pwr(0.5, 3)}
vg312 g312 0 {pwr(1, -2)}
vg313 g313 0 {pwr(1, -1)}
vg314 g314 0 {pwr(1, -0.5)}
vg315 g315 0 {pwr(1, 0)}
vg316 g316 0 {pwr(1, 0.5)}
vg317 g317 0 {pwr(1, 1)}
vg318 g318 0 {pwr(1, 2)}
vg319 g319 0 {pwr(1, 3)}
vg320 g320 0 {pwr(2.5, -2)}
vg321 g321 0 {pwr(2.5, -1)}
vg322 g322 0 {pwr(2.5, -0.5)}
vg323 g323 0 {pwr(2.5, 0)}
vg324 g324 0 {pwr(2.5, 0.5)}
vg325 g325 0 {pwr(2.5, 1)}
vg326 g326 0 {pwr(2.5, 2)}
vg327 g327 0 {pwr(2.5, 3)}
vg328 g328 0 {min(-2.5, -2.5)}
vg329 g329 0 {min(-2.5, -1)}
vg330 g330 0 {min(-2.5, -0.5)}
vg331 g331 0 {min(-2.5, 0)}
vg332 g332 0 {min(-2.5, 0.5)}
vg333 g333 0 {min(-2.5, 1)}
vg334 g334 0 {min(-2.5, 2.5)}
vg335 g335 0 {min(-1, -2.5)}
vg336 g336 0 {min(-1, -1)}
vg337 g337 0 {min(-1, -0.5)}
vg338 g338 0 {min(-1, 0)}
vg339 g339 0 {min(-1, 0.5)}
vg340 g340 0 {min(-1, 1)}
vg341 g341 0 {min(-1, 2.5)}
vg342 g342 0 {min(-0.5, -2.5)}
vg343 g343 0 {min(-0.5, -1)}
vg344 g344 0 {min(-0.5, -0.5)}
vg345 g345 0 {min(-0.5, 0)}
vg346 g346 0 {min(-0.5, 0.5)}
vg347 g347 0 {min(-0.5, 1)}
vg348 g348 0 {min(-0.5, 2.5)}
vg349 g349 0 {min(0, -2.5)}
vg350 g350 0 {min(0, -1)}
vg351 g351 0 {min(0, -0.5)}
vg352 g352 0 {min(0, 0)}
vg353 g353 0 {min(0, 0.5)}
vg354 g354 0 {min(0, 1)}
vg355 g355 0 {min(0, 2.5)}
vg356 g356 0 {min(0.5, -2.5)}
vg357 g357 0 {min(0.5, -1)}
vg358 g358 0 {min(0.5, -0.5)}
vg359 g359 0 {min(0.5, 0)}
vg360 g360 0 {min(0.5, 0.5)}
vg361 g361 0 {min(0.5, 1)}
vg362 g362 0 {min(0.5, 2.5)}
vg363 g363 0 {min(1, -2.5)}
vg364 g364 0 {min(1, -1)}
vg365 g365 0 {min(1, -0.5)}
vg366 g366 0 {min(1, 0)}
vg367 g367 0 {min(1, 0.5)}
vg368 g368 0 {min(1, 1)}
vg369 g369 0 {min(1, 2.5)}
vg370 g370 0 {min(2.5, -2.5)}
vg371 g371 0 {min(2.5, -1)}
vg372 g372 0 {min(2.5, -0.5)}
vg373 g373 0 {min(2.5, 0)}
vg374 g374 0 {min(2.5, 0.5)}
vg375 g375 0 {min(2.5, 1)}
vg376 g376 0 {min(2.5, 2.5)}
vg377 g377 0 {max(-2.5, -2.5)}
vg378 g378 0 {max(-2.5, -1)}
vg379 g379 0 {max(-2.5, -0.5)}
vg380 g380 0 {max(-2.5, 0)}
vg381 g381 0 {max(-2.5, 0.5)}
vg382 g382 0 {max(-2.5, 1)}
vg383 g383 0 {max(-2.5, 2.5)}
vg384 g384 0 {max(-1, -2.5)}
vg385 g385 0 {max(-1, -1)}
vg386 g386 0 {max(-1, -0.5)}
vg387 g387 0 {max(-1, 0)}
vg388 g388 0 {max(-1, 0.5)}
vg389 g389 0 {max(-1, 1)}
vg390 g390 0 {max(-1, 2.5)}
vg391 g391 0 {max(-0.5, -2.5)}
vg392 g392 0 {max(-0.5, -1)}
vg393 g393 0 {max(-0.5, -0.5)}
vg394 g394 0 {max(-0.5, 0)}
vg395 g395 0 {max(-0.5, 0.5)}
vg396 g396 0 {max(-0.5, 1)}
vg397 g397 0 {max(-0.5, 2.5)}
vg398 g398 0 {max(0, -2.5)}
vg399 g399 0 {max(0, -1)}
vg400 g400 0 {max(0, -0.5)}
vg401 g401 0 {max(0, 0)}
vg402 g402 0 {max(0, 0.5)}
vg403 g403 0 {max(0, 1)}
vg404 g404 0 {max(0, 2.5)}
vg405 g405 0 {max(0.5, -2.5)}
vg406 g406 0 {max(0.5, -1)}
vg407 g407 0 {max(0.5, -0.5)}
vg408 g408 0 {max(0.5, 0)}
vg409 g409 0 {max(0.5, 0.5)}
vg410 g410 0 {max(0.5, 1)}
vg411 g411 0 {max(0.5, 2.5)}
vg412 g412 0 {max(1, -2.5)}
vg413 g413 0 {max(1, -1)}
vg414 g414 0 {max(1, -0.5)}
vg415 g415 0 {max(1, 0)}
vg416 g416 0 {max(1, 0.5)}
vg417 g417 0 {max(1, 1)}
vg418 g418 0 {max(1, 2.5)}
vg419 g419 0 {max(2.5, -2.5)}
vg420 g420 0 {max(2.5, -1)}
vg421 g421 0 {max(2.5, -0.5)}
vg422 g422 0 {max(2.5, 0)}
vg423 g423 0 {max(2.5, 0.5)}
vg424 g424 0 {max(2.5, 1)}
vg425 g425 0 {max(2.5, 2.5)}
vg426 g426 0 {int(-3)}
vg427 g427 0 {int(-2.5)}
vg428 g428 0 {int(-1.5)}
vg429 g429 0 {int(-1)}
vg430 g430 0 {int(-0.5)}
vg431 g431 0 {int(-1e-07)}
vg432 g432 0 {int(0)}
vg433 g433 0 {int(1e-07)}
vg434 g434 0 {int(0.5)}
vg435 g435 0 {int(1)}
vg436 g436 0 {int(1.5)}
vg437 g437 0 {int(2.5)}
vg438 g438 0 {int(3)}
vg439 g439 0 {int(-1000.0)}
vg440 g440 0 {int(1000.0)}
vg441 g441 0 {nint(-3)}
vg442 g442 0 {nint(-2.5)}
vg443 g443 0 {nint(-1.5)}
vg444 g444 0 {nint(-1)}
vg445 g445 0 {nint(-0.5)}
vg446 g446 0 {nint(-1e-07)}
vg447 g447 0 {nint(0)}
vg448 g448 0 {nint(1e-07)}
vg449 g449 0 {nint(0.5)}
vg450 g450 0 {nint(1)}
vg451 g451 0 {nint(1.5)}
vg452 g452 0 {nint(2.5)}
vg453 g453 0 {nint(3)}
vg454 g454 0 {nint(-1000.0)}
vg455 g455 0 {nint(1000.0)}
vg456 g456 0 {nint(-2.5)}
vg457 g457 0 {nint(2.5)}
vg458 g458 0 {nint(0.5)}
vg459 g459 0 {sgn(-3)}
vg460 g460 0 {sgn(-2.5)}
vg461 g461 0 {sgn(-1.5)}
vg462 g462 0 {sgn(-1)}
vg463 g463 0 {sgn(-0.5)}
vg464 g464 0 {sgn(-1e-07)}
vg465 g465 0 {sgn(0)}
vg466 g466 0 {sgn(1e-07)}
vg467 g467 0 {sgn(0.5)}
vg468 g468 0 {sgn(1)}
vg469 g469 0 {sgn(1.5)}
vg470 g470 0 {sgn(2.5)}
vg471 g471 0 {sgn(3)}
vg472 g472 0 {sgn(-1000.0)}
vg473 g473 0 {sgn(1000.0)}
vg474 g474 0 {ceil(-3)}
vg475 g475 0 {ceil(-2.5)}
vg476 g476 0 {ceil(-1.5)}
vg477 g477 0 {ceil(-1)}
vg478 g478 0 {ceil(-0.5)}
vg479 g479 0 {ceil(-1e-07)}
vg480 g480 0 {ceil(0)}
vg481 g481 0 {ceil(1e-07)}
vg482 g482 0 {ceil(0.5)}
vg483 g483 0 {ceil(1)}
vg484 g484 0 {ceil(1.5)}
vg485 g485 0 {ceil(2.5)}
vg486 g486 0 {ceil(3)}
vg487 g487 0 {ceil(-1000.0)}
vg488 g488 0 {ceil(1000.0)}
vg489 g489 0 {floor(-3)}
vg490 g490 0 {floor(-2.5)}
vg491 g491 0 {floor(-1.5)}
vg492 g492 0 {floor(-1)}
vg493 g493 0 {floor(-0.5)}
vg494 g494 0 {floor(-1e-07)}
vg495 g495 0 {floor(0)}
vg496 g496 0 {floor(1e-07)}
vg497 g497 0 {floor(0.5)}
vg498 g498 0 {floor(1)}
vg499 g499 0 {floor(1.5)}
vg500 g500 0 {floor(2.5)}
vg501 g501 0 {floor(3)}
vg502 g502 0 {floor(-1000.0)}
vg503 g503 0 {floor(1000.0)}
vg504 g504 0 {sqr(-3)}
vg505 g505 0 {sqr(-2.5)}
vg506 g506 0 {sqr(-1.5)}
vg507 g507 0 {sqr(-1)}
vg508 g508 0 {sqr(-0.5)}
vg509 g509 0 {sqr(-1e-07)}
vg510 g510 0 {sqr(0)}
vg511 g511 0 {sqr(1e-07)}
vg512 g512 0 {sqr(0.5)}
vg513 g513 0 {sqr(1)}
vg514 g514 0 {sqr(1.5)}
vg515 g515 0 {sqr(2.5)}
vg516 g516 0 {sqr(3)}
vg517 g517 0 {sqr(-1000.0)}
vg518 g518 0 {sqr(1000.0)}
vg519 g519 0 {(-2.5)**(-2)}
vg520 g520 0 {(-2.5)**(-1)}
vg521 g521 0 {(-2.5)**(-0.5)}
vg522 g522 0 {(-2.5)**(0)}
vg523 g523 0 {(-2.5)**(0.5)}
vg524 g524 0 {(-2.5)**(1)}
vg525 g525 0 {(-2.5)**(2)}
vg526 g526 0 {(-2.5)**(3)}
vg527 g527 0 {(-1)**(-2)}
vg528 g528 0 {(-1)**(-1)}
vg529 g529 0 {(-1)**(-0.5)}
vg530 g530 0 {(-1)**(0)}
vg531 g531 0 {(-1)**(0.5)}
vg532 g532 0 {(-1)**(1)}
vg533 g533 0 {(-1)**(2)}
vg534 g534 0 {(-1)**(3)}
vg535 g535 0 {(-0.5)**(-2)}
vg536 g536 0 {(-0.5)**(-1)}
vg537 g537 0 {(-0.5)**(-0.5)}
vg538 g538 0 {(-0.5)**(0)}
vg539 g539 0 {(-0.5)**(0.5)}
vg540 g540 0 {(-0.5)**(1)}
vg541 g541 0 {(-0.5)**(2)}
vg542 g542 0 {(-0.5)**(3)}
vg543 g543 0 {(0)**(0)}
vg544 g544 0 {(0)**(0.5)}
vg545 g545 0 {(0)**(1)}
vg546 g546 0 {(0)**(2)}
vg547 g547 0 {(0)**(3)}
vg548 g548 0 {(0.5)**(-2)}
vg549 g549 0 {(0.5)**(-1)}
vg550 g550 0 {(0.5)**(-0.5)}
vg551 g551 0 {(0.5)**(0)}
vg552 g552 0 {(0.5)**(0.5)}
vg553 g553 0 {(0.5)**(1)}
vg554 g554 0 {(0.5)**(2)}
vg555 g555 0 {(0.5)**(3)}
vg556 g556 0 {(1)**(-2)}
vg557 g557 0 {(1)**(-1)}
vg558 g558 0 {(1)**(-0.5)}
vg559 g559 0 {(1)**(0)}
vg560 g560 0 {(1)**(0.5)}
vg561 g561 0 {(1)**(1)}
vg562 g562 0 {(1)**(2)}
vg563 g563 0 {(1)**(3)}
vg564 g564 0 {(2.5)**(-2)}
vg565 g565 0 {(2.5)**(-1)}
vg566 g566 0 {(2.5)**(-0.5)}
vg567 g567 0 {(2.5)**(0)}
vg568 g568 0 {(2.5)**(0.5)}
vg569 g569 0 {(2.5)**(1)}
vg570 g570 0 {(2.5)**(2)}
vg571 g571 0 {(2.5)**(3)}
vg572 g572 0 {(-2.5)^(-2)}
vg573 g573 0 {(-2.5)^(-1)}
vg574 g574 0 {(-2.5)^(-0.5)}
vg575 g575 0 {(-2.5)^(0)}
vg576 g576 0 {(-2.5)^(0.5)}
vg577 g577 0 {(-2.5)^(1)}
vg578 g578 0 {(-2.5)^(2)}
vg579 g579 0 {(-2.5)^(3)}
vg580 g580 0 {(-1)^(-2)}
vg581 g581 0 {(-1)^(-1)}
vg582 g582 0 {(-1)^(-0.5)}
vg583 g583 0 {(-1)^(0)}
vg584 g584 0 {(-1)^(0.5)}
vg585 g585 0 {(-1)^(1)}
vg586 g586 0 {(-1)^(2)}
vg587 g587 0 {(-1)^(3)}
vg588 g588 0 {(-0.5)^(-2)}
vg589 g589 0 {(-0.5)^(-1)}
vg590 g590 0 {(-0.5)^(-0.5)}
vg591 g591 0 {(-0.5)^(0)}
vg592 g592 0 {(-0.5)^(0.5)}
vg593 g593 0 {(-0.5)^(1)}
vg594 g594 0 {(-0.5)^(2)}
vg595 g595 0 {(-0.5)^(3)}
vg596 g596 0 {(0)^(0)}
vg597 g597 0 {(0)^(0.5)}
vg598 g598 0 {(0)^(1)}
vg599 g599 0 {(0)^(2)}
vg600 g600 0 {(0)^(3)}
vg601 g601 0 {(0.5)^(-2)}
vg602 g602 0 {(0.5)^(-1)}
vg603 g603 0 {(0.5)^(-0.5)}
vg604 g604 0 {(0.5)^(0)}
vg605 g605 0 {(0.5)^(0.5)}
vg606 g606 0 {(0.5)^(1)}
vg607 g607 0 {(0.5)^(2)}
vg608 g608 0 {(0.5)^(3)}
vg609 g609 0 {(1)^(-2)}
vg610 g610 0 {(1)^(-1)}
vg611 g611 0 {(1)^(-0.5)}
vg612 g612 0 {(1)^(0)}
vg613 g613 0 {(1)^(0.5)}
vg614 g614 0 {(1)^(1)}
vg615 g615 0 {(1)^(2)}
vg616 g616 0 {(1)^(3)}
vg617 g617 0 {(2.5)^(-2)}
vg618 g618 0 {(2.5)^(-1)}
vg619 g619 0 {(2.5)^(-0.5)}
vg620 g620 0 {(2.5)^(0)}
vg621 g621 0 {(2.5)^(0.5)}
vg622 g622 0 {(2.5)^(1)}
vg623 g623 0 {(2.5)^(2)}
vg624 g624 0 {(2.5)^(3)}
vg625 g625 0 {(-2.5) % (-2.5)}
vg626 g626 0 {(-2.5) % (-1)}
vg627 g627 0 {(-2.5) % (-0.5)}
vg628 g628 0 {(-2.5) % (0.5)}
vg629 g629 0 {(-2.5) % (1)}
vg630 g630 0 {(-2.5) % (2.5)}
vg631 g631 0 {(-1) % (-2.5)}
vg632 g632 0 {(-1) % (-1)}
vg633 g633 0 {(-1) % (-0.5)}
vg634 g634 0 {(-1) % (0.5)}
vg635 g635 0 {(-1) % (1)}
vg636 g636 0 {(-1) % (2.5)}
vg637 g637 0 {(-0.5) % (-2.5)}
vg638 g638 0 {(-0.5) % (-1)}
vg639 g639 0 {(-0.5) % (-0.5)}
vg640 g640 0 {(-0.5) % (0.5)}
vg641 g641 0 {(-0.5) % (1)}
vg642 g642 0 {(-0.5) % (2.5)}
vg643 g643 0 {(0) % (-2.5)}
vg644 g644 0 {(0) % (-1)}
vg645 g645 0 {(0) % (-0.5)}
vg646 g646 0 {(0) % (0.5)}
vg647 g647 0 {(0) % (1)}
vg648 g648 0 {(0) % (2.5)}
vg649 g649 0 {(0.5) % (-2.5)}
vg650 g650 0 {(0.5) % (-1)}
vg651 g651 0 {(0.5) % (-0.5)}
vg652 g652 0 {(0.5) % (0.5)}
vg653 g653 0 {(0.5) % (1)}
vg654 g654 0 {(0.5) % (2.5)}
vg655 g655 0 {(1) % (-2.5)}
vg656 g656 0 {(1) % (-1)}
vg657 g657 0 {(1) % (-0.5)}
vg658 g658 0 {(1) % (0.5)}
vg659 g659 0 {(1) % (1)}
vg660 g660 0 {(1) % (2.5)}
vg661 g661 0 {(2.5) % (-2.5)}
vg662 g662 0 {(2.5) % (-1)}
vg663 g663 0 {(2.5) % (-0.5)}
vg664 g664 0 {(2.5) % (0.5)}
vg665 g665 0 {(2.5) % (1)}
vg666 g666 0 {(2.5) % (2.5)}
vg667 g667 0 {(-2.5) \ (-2.5)}
vg668 g668 0 {(-2.5) \ (-1)}
vg669 g669 0 {(-2.5) \ (-0.5)}
vg670 g670 0 {(-2.5) \ (0.5)}
vg671 g671 0 {(-2.5) \ (1)}
vg672 g672 0 {(-2.5) \ (2.5)}
vg673 g673 0 {(-1) \ (-2.5)}
vg674 g674 0 {(-1) \ (-1)}
vg675 g675 0 {(-1) \ (-0.5)}
vg676 g676 0 {(-1) \ (0.5)}
vg677 g677 0 {(-1) \ (1)}
vg678 g678 0 {(-1) \ (2.5)}
vg679 g679 0 {(-0.5) \ (-2.5)}
vg680 g680 0 {(-0.5) \ (-1)}
vg681 g681 0 {(-0.5) \ (-0.5)}
vg682 g682 0 {(-0.5) \ (0.5)}
vg683 g683 0 {(-0.5) \ (1)}
vg684 g684 0 {(-0.5) \ (2.5)}
vg685 g685 0 {(0) \ (-2.5)}
vg686 g686 0 {(0) \ (-1)}
vg687 g687 0 {(0) \ (-0.5)}
vg688 g688 0 {(0) \ (0.5)}
vg689 g689 0 {(0) \ (1)}
vg690 g690 0 {(0) \ (2.5)}
vg691 g691 0 {(0.5) \ (-2.5)}
vg692 g692 0 {(0.5) \ (-1)}
vg693 g693 0 {(0.5) \ (-0.5)}
vg694 g694 0 {(0.5) \ (0.5)}
vg695 g695 0 {(0.5) \ (1)}
vg696 g696 0 {(0.5) \ (2.5)}
vg697 g697 0 {(1) \ (-2.5)}
vg698 g698 0 {(1) \ (-1)}
vg699 g699 0 {(1) \ (-0.5)}
vg700 g700 0 {(1) \ (0.5)}
vg701 g701 0 {(1) \ (1)}
vg702 g702 0 {(1) \ (2.5)}
vg703 g703 0 {(2.5) \ (-2.5)}
vg704 g704 0 {(2.5) \ (-1)}
vg705 g705 0 {(2.5) \ (-0.5)}
vg706 g706 0 {(2.5) \ (0.5)}
vg707 g707 0 {(2.5) \ (1)}
vg708 g708 0 {(2.5) \ (2.5)}
vg709 g709 0 {(-1) ? (2) : (3)}
vg710 g710 0 {ternary_fcn(-1, 2, 3)}
vg711 g711 0 {(0) ? (2) : (3)}
vg712 g712 0 {ternary_fcn(0, 2, 3)}
vg713 g713 0 {(0.5) ? (2) : (3)}
vg714 g714 0 {ternary_fcn(0.5, 2, 3)}
vg715 g715 0 {(1) ? (2) : (3)}
vg716 g716 0 {ternary_fcn(1, 2, 3)}
.op
.end
