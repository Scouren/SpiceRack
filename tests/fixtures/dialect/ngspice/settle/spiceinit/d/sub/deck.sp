spiceinit_d
* settle -b (HOME empty; ngbehavior=ps linearises B exp above 14, ptfuncs.c PTexp: ps gives 8.418230e+06, C exp(20) 4.851652e+08): parent lt, sub/ ps, run from d/ as sub/deck.sp: 8.418230e+06: with both, the deck folder's file wins
b1 o 0 v = exp(20)
r1 o 0 1k
.control
op
print v(o)
.endc
.end
