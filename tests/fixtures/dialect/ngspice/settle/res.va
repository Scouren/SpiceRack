`include "disciplines.vams"
module resva(p, n);
inout p, n; electrical p, n;
parameter real r = 1k;
analog I(p, n) <+ V(p, n) / r;
endmodule
