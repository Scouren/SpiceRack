grid_fold
* settle grid: values in the raw file (ngspice -b -r), compared with the IR's reference evaluator by tests/dialect_ngspice_grid.rs
bf0 f0 0 v = abs(-3)
bf1 f1 0 v = abs(-2.5)
bf2 f2 0 v = abs(-1.5)
bf3 f3 0 v = abs(-1)
bf4 f4 0 v = abs(-0.5)
bf5 f5 0 v = abs(-1e-07)
bf6 f6 0 v = abs(0)
bf7 f7 0 v = abs(1e-07)
bf8 f8 0 v = abs(0.5)
bf9 f9 0 v = abs(1)
bf10 f10 0 v = abs(1.5)
bf11 f11 0 v = abs(2.5)
bf12 f12 0 v = abs(3)
bf13 f13 0 v = abs(-1000.0)
bf14 f14 0 v = abs(1000.0)
bf15 f15 0 v = sqrt(0)
bf16 f16 0 v = sqrt(1e-07)
bf17 f17 0 v = sqrt(0.5)
bf18 f18 0 v = sqrt(1)
bf19 f19 0 v = sqrt(1.5)
bf20 f20 0 v = sqrt(2.5)
bf21 f21 0 v = sqrt(3)
bf22 f22 0 v = sqrt(1000.0)
bf23 f23 0 v = exp(-3)
bf24 f24 0 v = exp(-2.5)
bf25 f25 0 v = exp(-1.5)
bf26 f26 0 v = exp(-1)
bf27 f27 0 v = exp(-0.5)
bf28 f28 0 v = exp(-1e-07)
bf29 f29 0 v = exp(0)
bf30 f30 0 v = exp(1e-07)
bf31 f31 0 v = exp(0.5)
bf32 f32 0 v = exp(1)
bf33 f33 0 v = exp(1.5)
bf34 f34 0 v = exp(2.5)
bf35 f35 0 v = exp(3)
bf36 f36 0 v = exp(-30)
bf37 f37 0 v = exp(30)
bf38 f38 0 v = exp(-50)
bf39 f39 0 v = exp(50)
bf40 f40 0 v = exp(-250)
bf41 f41 0 v = exp(250)
bf42 f42 0 v = ln(1e-07)
bf43 f43 0 v = ln(0.5)
bf44 f44 0 v = ln(1)
bf45 f45 0 v = ln(1.5)
bf46 f46 0 v = ln(2.5)
bf47 f47 0 v = ln(3)
bf48 f48 0 v = ln(1000.0)
bf49 f49 0 v = log(1e-07)
bf50 f50 0 v = log(0.5)
bf51 f51 0 v = log(1)
bf52 f52 0 v = log(1.5)
bf53 f53 0 v = log(2.5)
bf54 f54 0 v = log(3)
bf55 f55 0 v = log(1000.0)
bf56 f56 0 v = log10(1e-07)
bf57 f57 0 v = log10(0.5)
bf58 f58 0 v = log10(1)
bf59 f59 0 v = log10(1.5)
bf60 f60 0 v = log10(2.5)
bf61 f61 0 v = log10(3)
bf62 f62 0 v = log10(1000.0)
bf63 f63 0 v = sin(-3)
bf64 f64 0 v = sin(-2.5)
bf65 f65 0 v = sin(-1.5)
bf66 f66 0 v = sin(-1)
bf67 f67 0 v = sin(-0.5)
bf68 f68 0 v = sin(-1e-07)
bf69 f69 0 v = sin(0)
bf70 f70 0 v = sin(1e-07)
bf71 f71 0 v = sin(0.5)
bf72 f72 0 v = sin(1)
bf73 f73 0 v = sin(1.5)
bf74 f74 0 v = sin(2.5)
bf75 f75 0 v = sin(3)
bf76 f76 0 v = sin(-1000.0)
bf77 f77 0 v = sin(1000.0)
bf78 f78 0 v = cos(-3)
bf79 f79 0 v = cos(-2.5)
bf80 f80 0 v = cos(-1.5)
bf81 f81 0 v = cos(-1)
bf82 f82 0 v = cos(-0.5)
bf83 f83 0 v = cos(-1e-07)
bf84 f84 0 v = cos(0)
bf85 f85 0 v = cos(1e-07)
bf86 f86 0 v = cos(0.5)
bf87 f87 0 v = cos(1)
bf88 f88 0 v = cos(1.5)
bf89 f89 0 v = cos(2.5)
bf90 f90 0 v = cos(3)
bf91 f91 0 v = cos(-1000.0)
bf92 f92 0 v = cos(1000.0)
bf93 f93 0 v = tan(-3)
bf94 f94 0 v = tan(-2.5)
bf95 f95 0 v = tan(-1.5)
bf96 f96 0 v = tan(-1)
bf97 f97 0 v = tan(-0.5)
bf98 f98 0 v = tan(-1e-07)
bf99 f99 0 v = tan(0)
bf100 f100 0 v = tan(1e-07)
bf101 f101 0 v = tan(0.5)
bf102 f102 0 v = tan(1)
bf103 f103 0 v = tan(1.5)
bf104 f104 0 v = tan(2.5)
bf105 f105 0 v = tan(3)
bf106 f106 0 v = tan(-1000.0)
bf107 f107 0 v = tan(1000.0)
bf108 f108 0 v = asin(-1)
bf109 f109 0 v = asin(-0.99)
bf110 f110 0 v = asin(-0.5)
bf111 f111 0 v = asin(-1e-07)
bf112 f112 0 v = asin(0)
bf113 f113 0 v = asin(1e-07)
bf114 f114 0 v = asin(0.5)
bf115 f115 0 v = asin(0.99)
bf116 f116 0 v = asin(1)
bf117 f117 0 v = acos(-1)
bf118 f118 0 v = acos(-0.99)
bf119 f119 0 v = acos(-0.5)
bf120 f120 0 v = acos(-1e-07)
bf121 f121 0 v = acos(0)
bf122 f122 0 v = acos(1e-07)
bf123 f123 0 v = acos(0.5)
bf124 f124 0 v = acos(0.99)
bf125 f125 0 v = acos(1)
bf126 f126 0 v = atan(-3)
bf127 f127 0 v = atan(-2.5)
bf128 f128 0 v = atan(-1.5)
bf129 f129 0 v = atan(-1)
bf130 f130 0 v = atan(-0.5)
bf131 f131 0 v = atan(-1e-07)
bf132 f132 0 v = atan(0)
bf133 f133 0 v = atan(1e-07)
bf134 f134 0 v = atan(0.5)
bf135 f135 0 v = atan(1)
bf136 f136 0 v = atan(1.5)
bf137 f137 0 v = atan(2.5)
bf138 f138 0 v = atan(3)
bf139 f139 0 v = atan(-1000.0)
bf140 f140 0 v = atan(1000.0)
bf141 f141 0 v = sinh(-3)
bf142 f142 0 v = sinh(-2.5)
bf143 f143 0 v = sinh(-1.5)
bf144 f144 0 v = sinh(-1)
bf145 f145 0 v = sinh(-0.5)
bf146 f146 0 v = sinh(-1e-07)
bf147 f147 0 v = sinh(0)
bf148 f148 0 v = sinh(1e-07)
bf149 f149 0 v = sinh(0.5)
bf150 f150 0 v = sinh(1)
bf151 f151 0 v = sinh(1.5)
bf152 f152 0 v = sinh(2.5)
bf153 f153 0 v = sinh(3)
bf154 f154 0 v = sinh(-30)
bf155 f155 0 v = sinh(30)
bf156 f156 0 v = cosh(-3)
bf157 f157 0 v = cosh(-2.5)
bf158 f158 0 v = cosh(-1.5)
bf159 f159 0 v = cosh(-1)
bf160 f160 0 v = cosh(-0.5)
bf161 f161 0 v = cosh(-1e-07)
bf162 f162 0 v = cosh(0)
bf163 f163 0 v = cosh(1e-07)
bf164 f164 0 v = cosh(0.5)
bf165 f165 0 v = cosh(1)
bf166 f166 0 v = cosh(1.5)
bf167 f167 0 v = cosh(2.5)
bf168 f168 0 v = cosh(3)
bf169 f169 0 v = cosh(-30)
bf170 f170 0 v = cosh(30)
bf171 f171 0 v = tanh(-3)
bf172 f172 0 v = tanh(-2.5)
bf173 f173 0 v = tanh(-1.5)
bf174 f174 0 v = tanh(-1)
bf175 f175 0 v = tanh(-0.5)
bf176 f176 0 v = tanh(-1e-07)
bf177 f177 0 v = tanh(0)
bf178 f178 0 v = tanh(1e-07)
bf179 f179 0 v = tanh(0.5)
bf180 f180 0 v = tanh(1)
bf181 f181 0 v = tanh(1.5)
bf182 f182 0 v = tanh(2.5)
bf183 f183 0 v = tanh(3)
bf184 f184 0 v = tanh(-1000.0)
bf185 f185 0 v = tanh(1000.0)
bf186 f186 0 v = asinh(-3)
bf187 f187 0 v = asinh(-2.5)
bf188 f188 0 v = asinh(-1.5)
bf189 f189 0 v = asinh(-1)
bf190 f190 0 v = asinh(-0.5)
bf191 f191 0 v = asinh(-1e-07)
bf192 f192 0 v = asinh(0)
bf193 f193 0 v = asinh(1e-07)
bf194 f194 0 v = asinh(0.5)
bf195 f195 0 v = asinh(1)
bf196 f196 0 v = asinh(1.5)
bf197 f197 0 v = asinh(2.5)
bf198 f198 0 v = asinh(3)
bf199 f199 0 v = asinh(-1000.0)
bf200 f200 0 v = asinh(1000.0)
bf201 f201 0 v = acosh(1)
bf202 f202 0 v = acosh(1.5)
bf203 f203 0 v = acosh(2.5)
bf204 f204 0 v = acosh(3)
bf205 f205 0 v = acosh(1000.0)
bf206 f206 0 v = atanh(-0.99)
bf207 f207 0 v = atanh(-0.5)
bf208 f208 0 v = atanh(-1e-07)
bf209 f209 0 v = atanh(0)
bf210 f210 0 v = atanh(1e-07)
bf211 f211 0 v = atanh(0.5)
bf212 f212 0 v = atanh(0.99)
bf213 f213 0 v = pow(-2.5, -2)
bf214 f214 0 v = pow(-2.5, -1)
bf215 f215 0 v = pow(-2.5, -0.5)
bf216 f216 0 v = pow(-2.5, 0)
bf217 f217 0 v = pow(-2.5, 0.5)
bf218 f218 0 v = pow(-2.5, 1)
bf219 f219 0 v = pow(-2.5, 2)
bf220 f220 0 v = pow(-2.5, 3)
bf221 f221 0 v = pow(-1, -2)
bf222 f222 0 v = pow(-1, -1)
bf223 f223 0 v = pow(-1, -0.5)
bf224 f224 0 v = pow(-1, 0)
bf225 f225 0 v = pow(-1, 0.5)
bf226 f226 0 v = pow(-1, 1)
bf227 f227 0 v = pow(-1, 2)
bf228 f228 0 v = pow(-1, 3)
bf229 f229 0 v = pow(-0.5, -2)
bf230 f230 0 v = pow(-0.5, -1)
bf231 f231 0 v = pow(-0.5, -0.5)
bf232 f232 0 v = pow(-0.5, 0)
bf233 f233 0 v = pow(-0.5, 0.5)
bf234 f234 0 v = pow(-0.5, 1)
bf235 f235 0 v = pow(-0.5, 2)
bf236 f236 0 v = pow(-0.5, 3)
bf237 f237 0 v = pow(0, 0)
bf238 f238 0 v = pow(0, 0.5)
bf239 f239 0 v = pow(0, 1)
bf240 f240 0 v = pow(0, 2)
bf241 f241 0 v = pow(0, 3)
bf242 f242 0 v = pow(0.5, -2)
bf243 f243 0 v = pow(0.5, -1)
bf244 f244 0 v = pow(0.5, -0.5)
bf245 f245 0 v = pow(0.5, 0)
bf246 f246 0 v = pow(0.5, 0.5)
bf247 f247 0 v = pow(0.5, 1)
bf248 f248 0 v = pow(0.5, 2)
bf249 f249 0 v = pow(0.5, 3)
bf250 f250 0 v = pow(1, -2)
bf251 f251 0 v = pow(1, -1)
bf252 f252 0 v = pow(1, -0.5)
bf253 f253 0 v = pow(1, 0)
bf254 f254 0 v = pow(1, 0.5)
bf255 f255 0 v = pow(1, 1)
bf256 f256 0 v = pow(1, 2)
bf257 f257 0 v = pow(1, 3)
bf258 f258 0 v = pow(2.5, -2)
bf259 f259 0 v = pow(2.5, -1)
bf260 f260 0 v = pow(2.5, -0.5)
bf261 f261 0 v = pow(2.5, 0)
bf262 f262 0 v = pow(2.5, 0.5)
bf263 f263 0 v = pow(2.5, 1)
bf264 f264 0 v = pow(2.5, 2)
bf265 f265 0 v = pow(2.5, 3)
bf266 f266 0 v = pwr(-2.5, -2)
bf267 f267 0 v = pwr(-2.5, -1)
bf268 f268 0 v = pwr(-2.5, -0.5)
bf269 f269 0 v = pwr(-2.5, 0)
bf270 f270 0 v = pwr(-2.5, 0.5)
bf271 f271 0 v = pwr(-2.5, 1)
bf272 f272 0 v = pwr(-2.5, 2)
bf273 f273 0 v = pwr(-2.5, 3)
bf274 f274 0 v = pwr(-1, -2)
bf275 f275 0 v = pwr(-1, -1)
bf276 f276 0 v = pwr(-1, -0.5)
bf277 f277 0 v = pwr(-1, 0)
bf278 f278 0 v = pwr(-1, 0.5)
bf279 f279 0 v = pwr(-1, 1)
bf280 f280 0 v = pwr(-1, 2)
bf281 f281 0 v = pwr(-1, 3)
bf282 f282 0 v = pwr(-0.5, -2)
bf283 f283 0 v = pwr(-0.5, -1)
bf284 f284 0 v = pwr(-0.5, -0.5)
bf285 f285 0 v = pwr(-0.5, 0)
bf286 f286 0 v = pwr(-0.5, 0.5)
bf287 f287 0 v = pwr(-0.5, 1)
bf288 f288 0 v = pwr(-0.5, 2)
bf289 f289 0 v = pwr(-0.5, 3)
bf290 f290 0 v = pwr(0, 0)
bf291 f291 0 v = pwr(0, 0.5)
bf292 f292 0 v = pwr(0, 1)
bf293 f293 0 v = pwr(0, 2)
bf294 f294 0 v = pwr(0, 3)
bf295 f295 0 v = pwr(0.5, -2)
bf296 f296 0 v = pwr(0.5, -1)
bf297 f297 0 v = pwr(0.5, -0.5)
bf298 f298 0 v = pwr(0.5, 0)
bf299 f299 0 v = pwr(0.5, 0.5)
bf300 f300 0 v = pwr(0.5, 1)
bf301 f301 0 v = pwr(0.5, 2)
bf302 f302 0 v = pwr(0.5, 3)
bf303 f303 0 v = pwr(1, -2)
bf304 f304 0 v = pwr(1, -1)
bf305 f305 0 v = pwr(1, -0.5)
bf306 f306 0 v = pwr(1, 0)
bf307 f307 0 v = pwr(1, 0.5)
bf308 f308 0 v = pwr(1, 1)
bf309 f309 0 v = pwr(1, 2)
bf310 f310 0 v = pwr(1, 3)
bf311 f311 0 v = pwr(2.5, -2)
bf312 f312 0 v = pwr(2.5, -1)
bf313 f313 0 v = pwr(2.5, -0.5)
bf314 f314 0 v = pwr(2.5, 0)
bf315 f315 0 v = pwr(2.5, 0.5)
bf316 f316 0 v = pwr(2.5, 1)
bf317 f317 0 v = pwr(2.5, 2)
bf318 f318 0 v = pwr(2.5, 3)
bf319 f319 0 v = min(-2.5, -2.5)
bf320 f320 0 v = min(-2.5, -1)
bf321 f321 0 v = min(-2.5, -0.5)
bf322 f322 0 v = min(-2.5, 0)
bf323 f323 0 v = min(-2.5, 0.5)
bf324 f324 0 v = min(-2.5, 1)
bf325 f325 0 v = min(-2.5, 2.5)
bf326 f326 0 v = min(-1, -2.5)
bf327 f327 0 v = min(-1, -1)
bf328 f328 0 v = min(-1, -0.5)
bf329 f329 0 v = min(-1, 0)
bf330 f330 0 v = min(-1, 0.5)
bf331 f331 0 v = min(-1, 1)
bf332 f332 0 v = min(-1, 2.5)
bf333 f333 0 v = min(-0.5, -2.5)
bf334 f334 0 v = min(-0.5, -1)
bf335 f335 0 v = min(-0.5, -0.5)
bf336 f336 0 v = min(-0.5, 0)
bf337 f337 0 v = min(-0.5, 0.5)
bf338 f338 0 v = min(-0.5, 1)
bf339 f339 0 v = min(-0.5, 2.5)
bf340 f340 0 v = min(0, -2.5)
bf341 f341 0 v = min(0, -1)
bf342 f342 0 v = min(0, -0.5)
bf343 f343 0 v = min(0, 0)
bf344 f344 0 v = min(0, 0.5)
bf345 f345 0 v = min(0, 1)
bf346 f346 0 v = min(0, 2.5)
bf347 f347 0 v = min(0.5, -2.5)
bf348 f348 0 v = min(0.5, -1)
bf349 f349 0 v = min(0.5, -0.5)
bf350 f350 0 v = min(0.5, 0)
bf351 f351 0 v = min(0.5, 0.5)
bf352 f352 0 v = min(0.5, 1)
bf353 f353 0 v = min(0.5, 2.5)
bf354 f354 0 v = min(1, -2.5)
bf355 f355 0 v = min(1, -1)
bf356 f356 0 v = min(1, -0.5)
bf357 f357 0 v = min(1, 0)
bf358 f358 0 v = min(1, 0.5)
bf359 f359 0 v = min(1, 1)
bf360 f360 0 v = min(1, 2.5)
bf361 f361 0 v = min(2.5, -2.5)
bf362 f362 0 v = min(2.5, -1)
bf363 f363 0 v = min(2.5, -0.5)
bf364 f364 0 v = min(2.5, 0)
bf365 f365 0 v = min(2.5, 0.5)
bf366 f366 0 v = min(2.5, 1)
bf367 f367 0 v = min(2.5, 2.5)
bf368 f368 0 v = max(-2.5, -2.5)
bf369 f369 0 v = max(-2.5, -1)
bf370 f370 0 v = max(-2.5, -0.5)
bf371 f371 0 v = max(-2.5, 0)
bf372 f372 0 v = max(-2.5, 0.5)
bf373 f373 0 v = max(-2.5, 1)
bf374 f374 0 v = max(-2.5, 2.5)
bf375 f375 0 v = max(-1, -2.5)
bf376 f376 0 v = max(-1, -1)
bf377 f377 0 v = max(-1, -0.5)
bf378 f378 0 v = max(-1, 0)
bf379 f379 0 v = max(-1, 0.5)
bf380 f380 0 v = max(-1, 1)
bf381 f381 0 v = max(-1, 2.5)
bf382 f382 0 v = max(-0.5, -2.5)
bf383 f383 0 v = max(-0.5, -1)
bf384 f384 0 v = max(-0.5, -0.5)
bf385 f385 0 v = max(-0.5, 0)
bf386 f386 0 v = max(-0.5, 0.5)
bf387 f387 0 v = max(-0.5, 1)
bf388 f388 0 v = max(-0.5, 2.5)
bf389 f389 0 v = max(0, -2.5)
bf390 f390 0 v = max(0, -1)
bf391 f391 0 v = max(0, -0.5)
bf392 f392 0 v = max(0, 0)
bf393 f393 0 v = max(0, 0.5)
bf394 f394 0 v = max(0, 1)
bf395 f395 0 v = max(0, 2.5)
bf396 f396 0 v = max(0.5, -2.5)
bf397 f397 0 v = max(0.5, -1)
bf398 f398 0 v = max(0.5, -0.5)
bf399 f399 0 v = max(0.5, 0)
bf400 f400 0 v = max(0.5, 0.5)
bf401 f401 0 v = max(0.5, 1)
bf402 f402 0 v = max(0.5, 2.5)
bf403 f403 0 v = max(1, -2.5)
bf404 f404 0 v = max(1, -1)
bf405 f405 0 v = max(1, -0.5)
bf406 f406 0 v = max(1, 0)
bf407 f407 0 v = max(1, 0.5)
bf408 f408 0 v = max(1, 1)
bf409 f409 0 v = max(1, 2.5)
bf410 f410 0 v = max(2.5, -2.5)
bf411 f411 0 v = max(2.5, -1)
bf412 f412 0 v = max(2.5, -0.5)
bf413 f413 0 v = max(2.5, 0)
bf414 f414 0 v = max(2.5, 0.5)
bf415 f415 0 v = max(2.5, 1)
bf416 f416 0 v = max(2.5, 2.5)
bf417 f417 0 v = nint(-3)
bf418 f418 0 v = nint(-2.5)
bf419 f419 0 v = nint(-1.5)
bf420 f420 0 v = nint(-1)
bf421 f421 0 v = nint(-0.5)
bf422 f422 0 v = nint(-1e-07)
bf423 f423 0 v = nint(0)
bf424 f424 0 v = nint(1e-07)
bf425 f425 0 v = nint(0.5)
bf426 f426 0 v = nint(1)
bf427 f427 0 v = nint(1.5)
bf428 f428 0 v = nint(2.5)
bf429 f429 0 v = nint(3)
bf430 f430 0 v = nint(-1000.0)
bf431 f431 0 v = nint(1000.0)
bf432 f432 0 v = nint(-2.5)
bf433 f433 0 v = nint(2.5)
bf434 f434 0 v = nint(0.5)
bf435 f435 0 v = sgn(-3)
bf436 f436 0 v = sgn(-2.5)
bf437 f437 0 v = sgn(-1.5)
bf438 f438 0 v = sgn(-1)
bf439 f439 0 v = sgn(-0.5)
bf440 f440 0 v = sgn(-1e-07)
bf441 f441 0 v = sgn(0)
bf442 f442 0 v = sgn(1e-07)
bf443 f443 0 v = sgn(0.5)
bf444 f444 0 v = sgn(1)
bf445 f445 0 v = sgn(1.5)
bf446 f446 0 v = sgn(2.5)
bf447 f447 0 v = sgn(3)
bf448 f448 0 v = sgn(-1000.0)
bf449 f449 0 v = sgn(1000.0)
bf450 f450 0 v = ceil(-3)
bf451 f451 0 v = ceil(-2.5)
bf452 f452 0 v = ceil(-1.5)
bf453 f453 0 v = ceil(-1)
bf454 f454 0 v = ceil(-0.5)
bf455 f455 0 v = ceil(-1e-07)
bf456 f456 0 v = ceil(0)
bf457 f457 0 v = ceil(1e-07)
bf458 f458 0 v = ceil(0.5)
bf459 f459 0 v = ceil(1)
bf460 f460 0 v = ceil(1.5)
bf461 f461 0 v = ceil(2.5)
bf462 f462 0 v = ceil(3)
bf463 f463 0 v = ceil(-1000.0)
bf464 f464 0 v = ceil(1000.0)
bf465 f465 0 v = floor(-3)
bf466 f466 0 v = floor(-2.5)
bf467 f467 0 v = floor(-1.5)
bf468 f468 0 v = floor(-1)
bf469 f469 0 v = floor(-0.5)
bf470 f470 0 v = floor(-1e-07)
bf471 f471 0 v = floor(0)
bf472 f472 0 v = floor(1e-07)
bf473 f473 0 v = floor(0.5)
bf474 f474 0 v = floor(1)
bf475 f475 0 v = floor(1.5)
bf476 f476 0 v = floor(2.5)
bf477 f477 0 v = floor(3)
bf478 f478 0 v = floor(-1000.0)
bf479 f479 0 v = floor(1000.0)
bf480 f480 0 v = uramp(-3)
bf481 f481 0 v = uramp(-2.5)
bf482 f482 0 v = uramp(-1.5)
bf483 f483 0 v = uramp(-1)
bf484 f484 0 v = uramp(-0.5)
bf485 f485 0 v = uramp(-1e-07)
bf486 f486 0 v = uramp(0)
bf487 f487 0 v = uramp(1e-07)
bf488 f488 0 v = uramp(0.5)
bf489 f489 0 v = uramp(1)
bf490 f490 0 v = uramp(1.5)
bf491 f491 0 v = uramp(2.5)
bf492 f492 0 v = uramp(3)
bf493 f493 0 v = uramp(-1000.0)
bf494 f494 0 v = uramp(1000.0)
bf495 f495 0 v = u(-3)
bf496 f496 0 v = u(-2.5)
bf497 f497 0 v = u(-1.5)
bf498 f498 0 v = u(-1)
bf499 f499 0 v = u(-0.5)
bf500 f500 0 v = u(-1e-07)
bf501 f501 0 v = u(0)
bf502 f502 0 v = u(1e-07)
bf503 f503 0 v = u(0.5)
bf504 f504 0 v = u(1)
bf505 f505 0 v = u(1.5)
bf506 f506 0 v = u(2.5)
bf507 f507 0 v = u(3)
bf508 f508 0 v = u(-1000.0)
bf509 f509 0 v = u(1000.0)
bf510 f510 0 v = u2(-3)
bf511 f511 0 v = u2(-2.5)
bf512 f512 0 v = u2(-1.5)
bf513 f513 0 v = u2(-1)
bf514 f514 0 v = u2(-0.5)
bf515 f515 0 v = u2(-1e-07)
bf516 f516 0 v = u2(0)
bf517 f517 0 v = u2(1e-07)
bf518 f518 0 v = u2(0.5)
bf519 f519 0 v = u2(1)
bf520 f520 0 v = u2(1.5)
bf521 f521 0 v = u2(2.5)
bf522 f522 0 v = u2(3)
bf523 f523 0 v = u2(-1000.0)
bf524 f524 0 v = u2(1000.0)
bf525 f525 0 v = u2(0.25)
bf526 f526 0 v = u2(0.75)
bf527 f527 0 v = (-2.5)**(-2)
bf528 f528 0 v = (-2.5)**(-1)
bf529 f529 0 v = (-2.5)**(-0.5)
bf530 f530 0 v = (-2.5)**(0)
bf531 f531 0 v = (-2.5)**(0.5)
bf532 f532 0 v = (-2.5)**(1)
bf533 f533 0 v = (-2.5)**(2)
bf534 f534 0 v = (-2.5)**(3)
bf535 f535 0 v = (-1)**(-2)
bf536 f536 0 v = (-1)**(-1)
bf537 f537 0 v = (-1)**(-0.5)
bf538 f538 0 v = (-1)**(0)
bf539 f539 0 v = (-1)**(0.5)
bf540 f540 0 v = (-1)**(1)
bf541 f541 0 v = (-1)**(2)
bf542 f542 0 v = (-1)**(3)
bf543 f543 0 v = (-0.5)**(-2)
bf544 f544 0 v = (-0.5)**(-1)
bf545 f545 0 v = (-0.5)**(-0.5)
bf546 f546 0 v = (-0.5)**(0)
bf547 f547 0 v = (-0.5)**(0.5)
bf548 f548 0 v = (-0.5)**(1)
bf549 f549 0 v = (-0.5)**(2)
bf550 f550 0 v = (-0.5)**(3)
bf551 f551 0 v = (0)**(0)
bf552 f552 0 v = (0)**(0.5)
bf553 f553 0 v = (0)**(1)
bf554 f554 0 v = (0)**(2)
bf555 f555 0 v = (0)**(3)
bf556 f556 0 v = (0.5)**(-2)
bf557 f557 0 v = (0.5)**(-1)
bf558 f558 0 v = (0.5)**(-0.5)
bf559 f559 0 v = (0.5)**(0)
bf560 f560 0 v = (0.5)**(0.5)
bf561 f561 0 v = (0.5)**(1)
bf562 f562 0 v = (0.5)**(2)
bf563 f563 0 v = (0.5)**(3)
bf564 f564 0 v = (1)**(-2)
bf565 f565 0 v = (1)**(-1)
bf566 f566 0 v = (1)**(-0.5)
bf567 f567 0 v = (1)**(0)
bf568 f568 0 v = (1)**(0.5)
bf569 f569 0 v = (1)**(1)
bf570 f570 0 v = (1)**(2)
bf571 f571 0 v = (1)**(3)
bf572 f572 0 v = (2.5)**(-2)
bf573 f573 0 v = (2.5)**(-1)
bf574 f574 0 v = (2.5)**(-0.5)
bf575 f575 0 v = (2.5)**(0)
bf576 f576 0 v = (2.5)**(0.5)
bf577 f577 0 v = (2.5)**(1)
bf578 f578 0 v = (2.5)**(2)
bf579 f579 0 v = (2.5)**(3)
bf580 f580 0 v = (-2.5)^(-2)
bf581 f581 0 v = (-2.5)^(-1)
bf582 f582 0 v = (-2.5)^(-0.5)
bf583 f583 0 v = (-2.5)^(0)
bf584 f584 0 v = (-2.5)^(0.5)
bf585 f585 0 v = (-2.5)^(1)
bf586 f586 0 v = (-2.5)^(2)
bf587 f587 0 v = (-2.5)^(3)
bf588 f588 0 v = (-1)^(-2)
bf589 f589 0 v = (-1)^(-1)
bf590 f590 0 v = (-1)^(-0.5)
bf591 f591 0 v = (-1)^(0)
bf592 f592 0 v = (-1)^(0.5)
bf593 f593 0 v = (-1)^(1)
bf594 f594 0 v = (-1)^(2)
bf595 f595 0 v = (-1)^(3)
bf596 f596 0 v = (-0.5)^(-2)
bf597 f597 0 v = (-0.5)^(-1)
bf598 f598 0 v = (-0.5)^(-0.5)
bf599 f599 0 v = (-0.5)^(0)
bf600 f600 0 v = (-0.5)^(0.5)
bf601 f601 0 v = (-0.5)^(1)
bf602 f602 0 v = (-0.5)^(2)
bf603 f603 0 v = (-0.5)^(3)
bf604 f604 0 v = (0)^(0)
bf605 f605 0 v = (0)^(0.5)
bf606 f606 0 v = (0)^(1)
bf607 f607 0 v = (0)^(2)
bf608 f608 0 v = (0)^(3)
bf609 f609 0 v = (0.5)^(-2)
bf610 f610 0 v = (0.5)^(-1)
bf611 f611 0 v = (0.5)^(-0.5)
bf612 f612 0 v = (0.5)^(0)
bf613 f613 0 v = (0.5)^(0.5)
bf614 f614 0 v = (0.5)^(1)
bf615 f615 0 v = (0.5)^(2)
bf616 f616 0 v = (0.5)^(3)
bf617 f617 0 v = (1)^(-2)
bf618 f618 0 v = (1)^(-1)
bf619 f619 0 v = (1)^(-0.5)
bf620 f620 0 v = (1)^(0)
bf621 f621 0 v = (1)^(0.5)
bf622 f622 0 v = (1)^(1)
bf623 f623 0 v = (1)^(2)
bf624 f624 0 v = (1)^(3)
bf625 f625 0 v = (2.5)^(-2)
bf626 f626 0 v = (2.5)^(-1)
bf627 f627 0 v = (2.5)^(-0.5)
bf628 f628 0 v = (2.5)^(0)
bf629 f629 0 v = (2.5)^(0.5)
bf630 f630 0 v = (2.5)^(1)
bf631 f631 0 v = (2.5)^(2)
bf632 f632 0 v = (2.5)^(3)
bf633 f633 0 v = (-1) ? (2) : (3)
bf634 f634 0 v = ternary_fcn(-1, 2, 3)
bf635 f635 0 v = (0) ? (2) : (3)
bf636 f636 0 v = ternary_fcn(0, 2, 3)
bf637 f637 0 v = (0.5) ? (2) : (3)
bf638 f638 0 v = ternary_fcn(0.5, 2, 3)
bf639 f639 0 v = (1) ? (2) : (3)
bf640 f640 0 v = ternary_fcn(1, 2, 3)
bf641 f641 0 v = sin(10000000000.0)
bf642 f642 0 v = sin(20000000000.0)
bf643 f643 0 v = sin(-20000000000.0)
bf644 f644 0 v = cos(100000000000.0)
bf645 f645 0 v = tan(10000000000.0)
bf646 f646 0 v = exp(1000.0)
bf647 f647 0 v = ln(0)
bf648 f648 0 v = log(0)
bf649 f649 0 v = log10(0)
.op
.end
