`include "disciplines.vams"
module resm(p, n);
inout p, n; electrical p, n;
parameter real r = 1k;
parameter real m = 1;
analog I(p, n) <+ m * V(p, n) / r;
endmodule
