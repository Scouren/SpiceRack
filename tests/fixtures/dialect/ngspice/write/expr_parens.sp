expr_parens
.param a={2 ** (3 ** 2)}
.param b={(-2) * 3}
.param c={-(2)}
.param d={1 - (2 - 3)}
.param e={1 ? (0 ? 4 : 8) : 16}
.param f={0 == 1 < 2}
.param g={0 == (1 < 2)}
.param h={!(a + b)}
.param i={3 * -2}
.end
