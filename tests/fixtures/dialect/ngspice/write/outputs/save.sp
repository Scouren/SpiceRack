save
.save all v(a) i(v1) @m1[gm] v(x1.x2.n) i(l.x1.l3) @m.x1.m2[id]
.end
