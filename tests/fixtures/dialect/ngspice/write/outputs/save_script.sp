save_script
.control
save all v(a) i(v1)
.endc
.end
