print
.print tran v(a) v(a,b) i(v1)
.print ac vdb(out) vp(out) vm(out) vr(out) v(out)
.print dc v(out)
.end
