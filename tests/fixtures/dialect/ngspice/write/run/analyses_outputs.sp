analyses_outputs
.noise v(a,b) vin oct 5 1 10 2
.tf i(vx) vin
.sens v(x1.b) ac dec 10 1 1k
.four 1k v(out) i(v1)
.end
