interleaved
.options reltol=1e-4
V1 a 0 dc 1
.op
R1 a 0 1k
.temp 50
.tran 1n 1u
.end
