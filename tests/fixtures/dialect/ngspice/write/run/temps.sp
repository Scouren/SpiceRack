temps
.options temp=85
.options temp=60
.options tnom=40
.end
