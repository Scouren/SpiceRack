state
.op
.options reltol=1e-4
.options method=trap
.options srcsteps=5
.options interp
.options temp=60 tnom=50
.options tnom=40
.ic v(x1.b)=0.5
.nodeset all=0.1
.end
