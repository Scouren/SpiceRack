model_value
R1 n 0 rmod {1k * 3}
C1 n 0 cmod 3n
L1 n 0 lmod {1m * 3}
R2 n 0 rmod 3k
.end
