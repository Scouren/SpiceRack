numbers
.param a=100u
.param b=0.050000
.param c=1meg
.param d=1.5e-3
.end
