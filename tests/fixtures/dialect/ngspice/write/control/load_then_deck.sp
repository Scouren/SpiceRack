load_then_deck
.control
pre_osdi a.osdi
.endc
* c
.control
pre_osdi b.osdi
.endc
.if (1)
* d
.endif
.end
