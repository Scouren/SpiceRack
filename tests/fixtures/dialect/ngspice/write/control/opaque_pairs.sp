opaque_pairs
.control
echo a
echo b
.endc
.op
.control
echo c
.endc
.end
