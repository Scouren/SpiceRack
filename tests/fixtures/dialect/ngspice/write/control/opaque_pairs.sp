opaque_pairs
.control
echo a
echo b
op
echo c
.endc
.end
