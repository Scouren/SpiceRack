script_alter
r1 a 0 1k
.control
alter r1 2k
op
.endc
.end
