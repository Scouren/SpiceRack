script_alter
.control
alter r1 2k
op
.endc
.end
