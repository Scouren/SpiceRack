script_option
.control
option reltol=0.01
option temp=60
op
.endc
.end
