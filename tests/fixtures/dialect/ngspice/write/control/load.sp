load
.control
pre_osdi res.osdi
.endc
.op
.end
