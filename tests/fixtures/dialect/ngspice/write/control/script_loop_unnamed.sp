script_loop_unnamed
.control
foreach sr1 1 2
alter v1 $sr1
op
end
.endc
.end
