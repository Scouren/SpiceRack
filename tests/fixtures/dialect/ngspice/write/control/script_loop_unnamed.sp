script_loop_unnamed
v1 a 0 dc 1
.control
foreach sr1 1 2
alter v1 $sr1
op
end
.endc
.end
