values
.param vt=0.45
.model m1 nmos vto={vt * 2} kp=vt lambda=-0.02 phi=2mil tox=1.5e-8 gamma=0.5 cj=100u
.end
