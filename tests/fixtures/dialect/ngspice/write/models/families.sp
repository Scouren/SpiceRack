families
.model a r
.model b c
.model c l
.model d d
.model e d level=3
.model f pnp
.model g npn level=4 vers=1.2
.model h npn level=8 version=2.4.0
.model i nmos
.model j pmos level=2
.model k nmos level=3
.model l nmos level=4
.model m nmos level=5
.model n nmos level=6
.model o nmos level=9
.model p nmos level=49 version=3.3.0
.model q pmos level=54 version=4.8.3
.model r nmos level=10 version=4.4
.model s nmos level=55 version=2.0
.model t nmos level=56 version=2.0
.model u nmos level=57 version=2.0
.model v nmos level=60
.model w nmos level=68 version=280
.model x nmos level=73 version=2.20
.model y vdmos pchan
.model z njf
.model aa pjf level=2
.model ab nmf
.model ac nhfet level=5
.model ad phfet level=6
.model ae sw
.model af csw
.model ag ltra
.model ah txl
.model ai cpl
.model aj urc
.model ak d_and
.model al mymod
.end
