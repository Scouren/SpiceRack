param_reads_circuit
* oracle: INV-semantics 2.06 (numparam evaluates a .param once and has no v(), i(), time, temper, hertz)
.param p={v(a)*2}
