title_comments_end
* oracle: INV-semantics 14.12 (line 1 is the title), 11.07 (ngspice drops .end and reads on), manual 1.5 (* lines)
.param a=1
  * an indented comment
.end
.param b=2
