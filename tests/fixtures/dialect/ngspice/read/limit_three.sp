limit_three
* oracle: xpressn.c formula (a 2-argument function gets the first and the last of 3: v, u) and limit (nom +- var); runs {limit(3,0,2)} = 5 (a draw of 3 +- 2), {min(5,9,2)} = 2, {pow(2,9,3)} = 8
.param a={limit(3,0,2)} b={min(5,9,2)}
