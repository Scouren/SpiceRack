* oracle: INV-semantics 14.12 (line 1 is the title, whatever it holds; R46: a blank line 1 is an empty title)
.param a=1
