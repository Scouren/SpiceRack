probe_unread
* oracle: ngspice-45 inpc_probe.c inp_probe: .probe is commented out, a deck with no save gets .save all, and 0 V sources (I()) or E sources (Vd()) are added at the devices it names; not a save
.probe v(a)
.probe alli
