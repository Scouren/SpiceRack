save_all_unread
* oracle: run: .save all, .save allv and no .save keep every node voltage and every branch current (e1#branch, l1#branch, v1#branch); the IR has no category for every branch current
.save all
.save alli
