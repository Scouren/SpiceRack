print_ac_parts
* oracle: ngspice-45 dotcards.c fixem (vm mag, vp ph in radians, vdb db, vr real); run: .print ac vm(a) vp(x1.n) vdb(x1.n) vr(x1.n) printed 1, 0, -6.02, 0.5
.print ac vm(a) vp(a) vdb(a,b) vr(a) v(a)
