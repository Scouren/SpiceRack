save_no_vector
* oracle: settle/device_outputs.sp (@i1[i] is an empty vector, @i1[c] one of 59), outputs.txt (the bjt has gm and go, no pi); the 38 decks' various/bjt_ac_par.sp
.save @q1[gm] @q1[pi] @q1[go]
.save @i1[i]
