include_lib
* oracle: INV-constructs A8 (.include, .inc), A11 (.lib file section), SPINE 2 (a path the sources lack stays as written)
.include "models/a.sp"
.lib 'corner.lib' TT
.inc gone.sp
