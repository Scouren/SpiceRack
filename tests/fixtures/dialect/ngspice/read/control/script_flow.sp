script_flow
* oracle: R49 (5): data-dependent flow (if, control.c) makes the whole script Script: every block of the deck
.control
op
.endc
.control
if 1
op
end
.endc
.end
