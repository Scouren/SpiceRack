hash_line
* oracle: S3-CONTROL O1, L1: a *# line outside a block is a script command (inp.c:777-797; settle/load_hash.sp, state_alterparam.sp)
*# pre_osdi res.osdi
*# echo hi
.control
op
.endc
.end
