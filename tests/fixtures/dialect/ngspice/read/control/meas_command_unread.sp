meas_command_unread
* oracle: lead's Q5: a script meas with two analyses of its kind measures only the current plot: Unread at its place
.control
tran 1u 5u
tran 1u 10u
meas tran mx max v(b)
.endc
.end
