run_with_cards
* oracle: R49 (3): a script that changes no state: the card stands once, run is framing (settle/order_run_one_card.sp); plot is display
.tran 1u 5u
.control
run
plot v(b)
.endc
.end
