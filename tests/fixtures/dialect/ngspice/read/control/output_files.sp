output_files
* oracle: R49 (5), the lead's dc_loop finding (spice-bench examples/various/dc_loop.sp keeps its derived vectors in dc_loop.out): a command writing vectors to a file (commands.c write, wrdata, wrs2p, eprvcd) states nothing the IR holds and is the deck's product: Private, never a display command a conversion may drop
.control
op
let k = v(b)*2
write out.raw k
wrdata out.txt v(b)
.endc
.end
