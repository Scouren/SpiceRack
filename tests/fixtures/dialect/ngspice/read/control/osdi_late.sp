osdi_late
* oracle: S3-CONTROL L1: a plain osdi runs after the parse, too late for the deck (settle/load_late.sp): InvalidInSource
.control
osdi res.osdi
op
.endc
.end
