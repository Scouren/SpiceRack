unclosed
* oracle: a block the file ends before closing runs to the end of the file (inp.c:742-812: commands until .endc; corpus Monte_Carlo/MC_ring_ts.sp); kept whole with its .endc, so a written .end stays outside
.op
.control
if 1
op
end
