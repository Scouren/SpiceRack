pre_osdi
* oracle: S3-CONTROL L1: pre_osdi loads before the parse, relative to the deck (inp.c:791-797, :847-859; settle/load_ctl.sp)
.control
pre_osdi res.osdi
.endc
.control
op
.endc
.end
