save_later
* oracle: A28: a script save after an analysis holds from there (settle/state_save_reset.sp: op2 after the reset saves everything again)
.control
op
save v(b)
tran 1u 5u
.endc
.end
