save_card_late
* oracle: R49 (3): with a dot card, a script save after an analysis is a state change the cards' runs see: the whole script Script
.op
.control
tran 1u 5u
save v(b)
.endc
.end
