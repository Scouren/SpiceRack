script_effect
* oracle: S3-CONTROL §2: source runs another file at run time (commands.c:501): Script
.control
source other.cir
op
.endc
.end
