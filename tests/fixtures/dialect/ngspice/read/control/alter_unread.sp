alter_unread
* oracle: R49 (5), lead's Q4: an alter of a vector parameter, a frontend expression value, a subcircuit element: Unread at its place
.control
alter @v1[pulse]=[ 0 1 1n 1n 1n 5n 10n ]
alter r1 = 2*1k
alter r.x1.r2 1k
op
.endc
.end
