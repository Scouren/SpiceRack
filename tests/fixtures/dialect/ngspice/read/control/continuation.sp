continuation
* oracle: S3-CONTROL O1: '+' continues a script line (settle/state_alterparam.sp); an inert command keeps its lines
.control
echo a
+ b
op
.endc
.end
