save_card
* oracle: lead's Q6: with a dot card, a script save before the script's first analysis and with no reset in it is the deck's .save (the cards run at run and after the script, inp.c, main.c:1547-1555)
.op
.control
save v(b)
run
.endc
.end
