foreach_unrolled
* oracle: S3-CONTROL V1: an analysis that reads the variable is not the Loop law: the loop unrolled, each word substituted as written
v1 a 0 1
.control
foreach v 1 2
dc v1 $v $v 1
end
.endc
.end
