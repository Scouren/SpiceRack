option_commands
* oracle: S3-CONTROL S3: option k=v and set k=v of a simulator option hold from here (com_option.c:104-131, options.c:444-450; settle/state_option_temp.sp)
.control
option reltol=0.01
set temp=60
option temp=50 tnom=40
op
.endc
.end
