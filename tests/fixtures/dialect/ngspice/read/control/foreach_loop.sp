foreach_loop
* oracle: S3-CONTROL V1, S5: a foreach word is the word as written (control.c:465) and the target keeps the last value (settle/subst.sp): Loop, KeepLast, Loop.name the variable (lead's Q3)
r1 a 0 1k
.control
foreach v 1k
+ 2.2k
alter r1 $v
op
end
.endc
.end
