meas_card_run
* oracle: lead's Q5: a script meas after the one run that runs the deck's one card of its kind (the card before the script) is the deck's .meas: written as a script the card is a command before it (corpus measure/buggy-meas-tran.sp)
.tran 1u 5u
.control
run
meas tran mx max v(b)
.endc
.end
