save_command
* oracle: A28: in a deck with no dot card a script save holds from where it stands (settle/state_save_reset.sp: op1 keeps b only), and reset restores it
.control
save v(b)
op
.endc
.end
