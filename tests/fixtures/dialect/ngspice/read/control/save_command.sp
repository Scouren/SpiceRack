save_command
* oracle: lead's Q6: a script save before the first analysis with no reset after it is the deck's .save (settle/state_save_reset.sp)
.control
save v(b)
op
.endc
.end
