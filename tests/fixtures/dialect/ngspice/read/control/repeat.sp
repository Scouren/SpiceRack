repeat
* oracle: S3-CONTROL §2: repeat n with a literal n runs its body n times (control.c CO_REPEAT): unrolled
.control
repeat 2
op
end
.endc
.end
