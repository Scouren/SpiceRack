no_command
* oracle: S3-CONTROL §2: a word that is no command (four, foo): ngspice says 'no such command available' (run): InvalidInSource at its place
.control
four 1k v(b)
op
.endc
.end
