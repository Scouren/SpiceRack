inert_commands
* oracle: S3-CONTROL §2: display commands move no number (commands.c echo, print, let, display, set of a display variable, quit); each its own .control pair (R49 (2), O1)
.control
echo start
op
print v(b)
let k = 2
display
set width=120
quit
.endc
.end
