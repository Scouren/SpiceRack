script_state_cards
* oracle: R49 (3): a script that changes state in a deck with a dot-card analysis is one Script opaque (settle/order_after_script.sp, order_script_and_card.sp)
.op
.control
alter r1 3k
.endc
.end
