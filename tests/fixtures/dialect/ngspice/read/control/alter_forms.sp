alter_forms
* oracle: S3-CONTROL S4: device.c:1249-1420 com_alter_common (bare value: the principal parameter, spiceif.c:951; dev p v, dev p = v, @dev[p] = v); names fold (inpcom.c:1775)
r1 a 0 1k
v1 a 0 1
c1 a 0 1p
.control
alter r1 2k
alter R1 = 3k
alter v1 1.5
alter @r1[resistance]=4k
alter r1 resistance 5k
alter c1 = 1p
op
.endc
.end
