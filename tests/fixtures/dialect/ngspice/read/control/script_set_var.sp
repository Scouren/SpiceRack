script_set_var
* oracle: S3-CONTROL V2: a set number is reprinted with %G (variable.c:41-56; settle/subst.sp): a typed command reading it makes the script Script
r1 a 0 1k
.control
set x = 2k
alter r1 $x
op
.endc
.end
