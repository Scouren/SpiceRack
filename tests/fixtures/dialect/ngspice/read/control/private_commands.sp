private_commands
* oracle: lead's Q4: setseed, optran, codemodel are ngspice's own: Private at their place
.control
setseed 3
op
.endc
.end
