run_no_cards
* oracle: R49 (3): run with no dot-card analysis runs nothing (runcoms.c dosim; settle/order_run_no_card.sp): framing
.control
op
run
.endc
.end
