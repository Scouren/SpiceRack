meas_command
* oracle: lead's Q5: a script meas after the script's one analysis of its kind is the deck's .meas (measure.c:37 com_meas, runcoms.c:395-397)
.control
tran 1u 5u
meas tran mx max v(b)
.endc
.end
