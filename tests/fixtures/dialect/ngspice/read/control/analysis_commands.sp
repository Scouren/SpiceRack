analysis_commands
* oracle: R49 (3): with no dot-card analysis the script's analysis commands are the plan (commands.c:297-347; settle/order_two_blocks.sp)
.control
op
tran 1u 5u
ac dec 2 1 1k
.endc
.end
