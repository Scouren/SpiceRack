save_later_unread
* oracle: lead's Q6: a script save after an analysis holds from there (settle/state_save_reset.sp): Unread until Save.holds
.control
op
save v(b)
tran 1u 5u
.endc
.end
