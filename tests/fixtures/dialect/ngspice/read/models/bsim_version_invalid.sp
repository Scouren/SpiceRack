bsim_version_invalid
* oracle: inpdomod.c (a BSIM3, BSIM4 or HiSIM-HV version none of its prefixes match: Device type BSIM4 version %s not available), run: version=4.9 could not find a valid modelname
.model n4 nmos level=54 version=4.9
.model n3 nmos level=49 version=2.0
.model hv nmos level=73 version=3.0
