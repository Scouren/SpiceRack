hisim2
* oracle: inpdomod.c level 68 (HiSIM2), hsm2set.c:133 (a silent version is 280), hsm2.c model table (tox vfbc xld)
.model h1 nmos level=68 tox=3n vfbc=-1
.model h2 pmos level=68 version=280 xld=1e-8
