duplicate
* oracle: inpmkmod.c INPmakeMod (a model name already in the table is kept: the first card wins), run: is=1e-14 then is=1e-12 gives the is=1e-14 current
.model dd d is=1e-14
.model dd d is=1e-12
.model DD d is=1e-10
