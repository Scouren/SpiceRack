params_ignored
* oracle: inpgmod.c create_model (a name no IFparm table of the device has is unrecognized parameter - ignored; level and m skipped unless model parameters; a repeated parameter is set again), runs: foo=3 and m=2 on nmos change nothing
.model m1 nmos vto=0.5 foo=3 kp=1e-4 m=2 kp=2e-4
.model d1 d m=0.4
.model r1 r level=2 r=5
.model m2 nmos l=1u version=1
