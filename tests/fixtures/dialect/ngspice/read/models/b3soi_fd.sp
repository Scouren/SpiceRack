b3soi_fd
* oracle: inpdomod.c level 55 (B3SOIFD), b3soifdset.c:69 (the version parameter, default 2.0, is never read again: any value runs the device, which implements B3SOI 2.1 (devhelp), the IR vocabulary's string, ir-circuit 48abdc5f), b3soifd.c model table (tox tsi tbox vth0)
.model f1 nmos level=55 tox=8n tsi=1e-7
.model f2 pmos level=55 version=2.1 tbox=4e-7 vth0=-0.5
