unread_forms
* oracle: INPfindLev (a level in braces is numparam's before the card is read), inptyplk.c (a device name as type word), create_model (a bare flag)
.model mb nmos level={lv}
.model mc bsim4 level=54
.model me nmos level=1 pmos
.model mf cpl r=0.1 0 0.1
.model mg nmos vto={v(a)}
