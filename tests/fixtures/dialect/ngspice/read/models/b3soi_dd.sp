b3soi_dd
* oracle: inpdomod.c level 56 (B3SOIDD), b3soiddset.c:69 (a silent version is 2.0), b3soidd.c model table (tox tsi nsub u0)
.model d1 nmos level=56 tox=8n nsub=6e16
.model d2 pmos level=56 version=2.1 u0=250
