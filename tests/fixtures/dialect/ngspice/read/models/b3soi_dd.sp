b3soi_dd
* oracle: inpdomod.c level 56 (B3SOIDD), b3soiddset.c:69 (the version parameter, default 2.0, is never read again: any value runs the device, which implements B3SOI 2.1 (devhelp), the IR vocabulary's string, ir-circuit 48abdc5f), b3soidd.c model table (tox tsi nsub u0)
.model d1 nmos level=56 tox=8n nsub=6e16
.model d2 pmos level=56 version=2.1 u0=250
