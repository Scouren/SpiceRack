code_module
* oracle: inpdomod.c default branch (INPtypelook: an XSPICE code model, devhelp lists d_and; any other word an OSDI module loaded by pre_osdi), CIDER numd (inp_cider_models: ngspice's own numerical device)
.model g1 d_and (rise_delay=1n fall_delay=2n)
.model va1 mymod (a=1)
.model c1 numd level=1
