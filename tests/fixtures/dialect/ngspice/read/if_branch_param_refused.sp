if_branch_param_refused
* oracle: manual 2.15 (a branch holds instances and models only; no .param, .subckt, .include, .lib)
.if (1)
.param p=1
.endif
