noise_current_refused
* oracle: ngspice-45 inp2dot.c:48 (only V(...) is an output); run: circuit not parsed
.noise i(v1) v1 dec 1 1 10
