tran_tmax_zero
* oracle: ngspice-45 traninit.c:29 (tmax 0 is no tmax: the default ceiling)
.tran 1n 1u 0 0
