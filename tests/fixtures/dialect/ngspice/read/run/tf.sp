tf
* oracle: ngspice-45 inp2dot.c dot_tf (v(n[,m]) or i(src), then the input source)
.tf v(b) v1
.tf v(a,b) v1
.tf i(vx) vin
