ic
* oracle: ngspice-45 inppas3.c:115-170 (.ic v(n)=x, by INPevaluate), INV-semantics 8.21 (held in the transient's operating point only); runs: the last of two on one node holds
.ic v(b)=0.5 v(x1.n)={vv}
.ic V(b) = 0.25
