dc_step_zero
* oracle: ngspice-45 inp2dot.c:313 (a zero step is Bad syntax), inp2dot.c:884-888
.dc v1 0 5 0
