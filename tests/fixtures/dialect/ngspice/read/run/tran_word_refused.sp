tran_word_refused
* oracle: ngspice-45 inp2dot.c:441-447 (unknown parameter on .tran); run: circuit not parsed
.tran 1u 10u bogus
