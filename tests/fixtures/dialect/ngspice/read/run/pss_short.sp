pss_short
* oracle: ngspice-45 inp2dot.c dot_pss (every argument is read from the line, given or not: a short card's reading is not established)
.pss 1k 1m b
