four
* oracle: ngspice-45 fourier.c:69-70 (nfreqs default 10: DC and 9 harmonics), inp2dot.c:870 (.four, .fourier)
.four 1k v(out) i(v1)
.fourier 50 v(a,b)
