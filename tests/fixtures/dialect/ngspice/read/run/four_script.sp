four_script
* oracle: ngspice-45 fourier.c:69 (cp_getvar nfreqs: a script set gives the count; the set is an option from its place on, R49 ii, and a count-less Four reads the deck-wide nfreqs only)
.four 1k v(out)
.control
set nfreqs=4
.endc
