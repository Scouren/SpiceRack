ac
* oracle: ngspice-45 inp2dot.c dot_ac (DEC|OCT|LIN np fstart fstop; lin np is the point count), acan.c
.ac dec 10 1 1meg
.ac oct 4 100 1k
.ac lin 11 0 1k
