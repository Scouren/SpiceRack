pz
* oracle: ngspice-45 inp2dot.c dot_pz (in+ in- out+ out- vol|cur pol|zer|pz), pzsetp.c:78-87
.pz a 0 b 0 vol pz
.pz in gnd out 0 cur pol
