ac_word_refused
* oracle: ngspice-45 inp2dot.c:200 (Missing DEC, OCT, or LIN); run: .ac decade 2 1 10 is circuit not parsed
.ac decade 2 1 10
