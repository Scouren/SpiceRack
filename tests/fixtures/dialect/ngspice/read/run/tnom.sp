tnom
* oracle: ngspice-45 cktsopt.c:268-269 (temp, tnom options; no .temp card in the deck: temp= holds)
.options tnom=50 temp=60
.option tnom=40
