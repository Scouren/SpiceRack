ic_dotted_net
* oracle: none yet: a pinned limit (ponytail in read_run/words.rs): a dotted node reads as an instance path, a top-level net named a.b included; the corpus run shows when it bites
.ic v(a.b)=1
