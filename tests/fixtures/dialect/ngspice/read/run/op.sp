op
* oracle: ngspice-45 inp2dot.c dot_op (no argument)
.op
