nodeset
* oracle: ngspice-45 inppas3.c:52-112 (.nodeset v(n)=x, all=x sets every voltage node)
.nodeset v(a)=0.1
.nodeset all=0.5
