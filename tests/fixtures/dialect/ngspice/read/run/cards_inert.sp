cards_inert
* oracle: ngspice-45 inp2dot.c:845 (.width ignored), frontend .csparam (a control-script vector); runs: both run on
.width in=72
.csparam x=1
