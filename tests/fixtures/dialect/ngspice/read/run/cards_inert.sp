cards_inert
* oracle: ngspice-45 inp2dot.c:955-959 (.prot, .unprot ignored), frontend .csparam (a control-script vector); runs: .csparam runs on
.csparam x=1
.prot
.unprot
