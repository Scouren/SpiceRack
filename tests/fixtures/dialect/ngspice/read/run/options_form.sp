options_form
* oracle: ngspice-45 cktsopt.c (reltol is IF_REAL); run: .options reltol 1e-4 is bad type given, the key left out
.options reltol 1e-4
