sp
* oracle: ngspice-45 inp2dot.c dot_sp (DEC|OCT|LIN np fstart fstop [donoise]), RFSPICE built (run)
.sp lin 2 1 10
.sp dec 10 1meg 1g 1
