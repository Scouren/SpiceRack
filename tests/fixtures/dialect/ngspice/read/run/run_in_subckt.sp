run_in_subckt
* oracle: R26, run sub.cir (an .op and an .options in a .subckt body run as the deck's)
.subckt s1 n
.op
.options reltol=0.5
.ends
