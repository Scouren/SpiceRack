sens
* oracle: ngspice-45 inp2dot.c dot_sens (output, then nothing, dc, or ac DEC|OCT|LIN np fstart fstop)
.sens v(b)
.sens i(v1) dc
.sens v(a,b) ac dec 10 1 1k
