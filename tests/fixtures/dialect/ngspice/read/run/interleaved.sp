interleaved
* oracle: ngspice-45 inp.c (state cards, elements and analyses read in any order: the common deck shape, 30 of 419 ngspice-45 examples, e.g. cider/bicmos/bicmpd.cir), RunInterleaved
.options reltol=1e-4
.temp 50
V1 a 0 1
R1 a 0 1k
.op
