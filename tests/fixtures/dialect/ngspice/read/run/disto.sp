disto
* oracle: ngspice-45 inp2dot.c dot_disto (DEC|OCT|LIN np fstart fstop [f2overf1])
.disto dec 5 1k 10k
.disto lin 3 1k 2k 0.9
