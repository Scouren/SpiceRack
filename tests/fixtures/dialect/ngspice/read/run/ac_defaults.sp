ac_defaults
* oracle: ngspice-45 inp2dot.c:205-231 (np < 1 is 10, fstop < fstart is 1000 fstart: ngspice runs other numbers)
.ac dec 0 1 1k
.ac dec 10 1k 1
