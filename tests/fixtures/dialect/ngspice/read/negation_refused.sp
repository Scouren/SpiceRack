negation_refused
* oracle: xpressn.c formula (a - after an operator negates the next number only), run {2*-q}: "wrongly determined negation"
.param q=3
.param p={2*-q}
