notes
* oracle: vsrcload.c (values past each wave's arity ignored; td and r only for PWL), inpdpar.c (the later keyword holds); runs: `sin(0 1 1k) pulse(5 6)` is the pulse
V1 a 0 sin(0 1 1k) pulse(5 6)
V2 b 0 sin(0 1 1k) td=1u
V3 c 0 exp(0 1 1u 1u 2u 1u 9)
.end
