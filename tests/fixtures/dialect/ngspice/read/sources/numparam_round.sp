numparam_round
* oracle: settle numparam_round.sp (a {…} or '…' numparam substitutes as '% 23.15e' text, which INPevaluate reads digit by digit: its 16 digits are the value; a bare number is read whole)
v1 a 0 '1.0453385141288605'
v2 b 0 {1.0453385141288605}
v3 c 0 1.0453385141288605
r1 a 0 '2.5'
