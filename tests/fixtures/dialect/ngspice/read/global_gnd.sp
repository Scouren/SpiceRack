global_gnd
* oracle: manual 2.6 (.global), INV-semantics 11.01 (gnd is node 0: inpcom.c inp_fix_gnd_name), 3.02 (names fold case)
.global vdd GND Vdd vss
