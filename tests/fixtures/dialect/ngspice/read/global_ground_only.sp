global_ground_only
* oracle: INV-semantics 11.01 (ground is global already)
.global gnd 0
