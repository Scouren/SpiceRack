numbers
* oracle: INV-semantics 1.01-1.07, R1 (digits as written), xpressn.c fetchnumber (numparam: no d exponent, mil is milli), runs {2mil} = 2e-3, {1e3k} = 1e6
.param a=100u b=1M c=1meg d=0.050000 e=1e3k f=2mil g=1.5e-3 h=10v
