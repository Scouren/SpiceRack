am_form
* settle (ESPice 0.3.0, --tokenizer=hspice; ESPice is not HSPICE): v(1) = 2.513e-4 at 20 ns, rising: AM(SA OC FM FC TD)
v1 1 0 am(2 1 100 1k 0)
r1 1 0 1k
.tran 0.05m 0.2m
.end
