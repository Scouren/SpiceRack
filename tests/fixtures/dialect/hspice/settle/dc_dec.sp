dc_dec
* settle (ESPice 0.3.0, --tokenizer=hspice; ESPice is not HSPICE): 1, 1.58489, 2.51189, 3.98107, ...: '.dc v1 dec 5 1 10'
v1 1 0 1
r1 1 0 1k
.dc v1 dec 5 1 10
.end
