mos1 (ngspice twin)
* settle (ngspice-45, -b): i(vd) = -1.69600003e-04
vd d 0 3
vg g 0 1.5
m1 d g 0 0 nm w=10u l=2u
.model nm nmos level=1 vto=0.7 kp=1e-4 lambda=0.02
.control
set numdgt=9
op
print i(vd)
.endc
.end
