law_log
vx x 0 0
e1 a 0 vol='ln(v(x))'
ra a 0 1k
.op
.end
