law_trig
vx x 0 0
e1 a 0 vol='sin(1e10+v(x))'
ra a 0 1k
.op
.end
