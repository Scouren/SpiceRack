law_exp
vx x 0 0
e1 a 0 vol='exp(228+v(x))'
ra a 0 1k
.op
.end
