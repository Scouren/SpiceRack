law_asin
vx x 0 0
e1 a 0 vol='asin(1+v(x))'
ra a 0 1k
.op
.end
