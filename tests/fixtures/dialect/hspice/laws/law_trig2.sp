law_trig2
vx x 0 0
e1 a 0 vol='sin(3e9*6.283185307179586+0.5+v(x))'
ra a 0 1k
.op
.end
