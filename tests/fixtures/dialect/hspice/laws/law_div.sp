law_div
vx x 0 0
e1 a 0 vol='1/(v(x))'
ra a 0 1k
.op
.end
