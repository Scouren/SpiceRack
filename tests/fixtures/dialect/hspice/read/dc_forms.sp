dc_forms
* settle (ESPice 0.3.0, --tokenizer=hspice; ESPice is not HSPICE): 1, 2, 3: '.dc v1 start=1 stop=3 step=1'
v1 1 0 1
r1 1 0 1k
.dc v1 start=1 stop=3 step=1
.end
