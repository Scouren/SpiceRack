cap ic=2 to ground under
* settle (device_ic_to_tran_ic): ngspice-45 -b -r: v(a) 0 throughout (ic read only under uic)
r1 a 0 1k
c1 a 0 1u ic=2
.tran 10u 1m
.end
