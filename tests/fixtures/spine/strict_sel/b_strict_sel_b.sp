b_strict_sel_b: a library section read by .lib b
.lib sel.lib.sp b
v1 n 0 1
r1 n 0 1k
.op
.end
