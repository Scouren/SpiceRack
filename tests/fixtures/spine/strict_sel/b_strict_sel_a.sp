b_strict_sel_a: a library section read by .lib a
.lib sel.lib.sp a
v1 n 0 1
r1 n 0 1k
.op
.end
