b_strict_sel_d: a library section read by .lib d
.lib sel.lib.sp d
v1 n 0 1
r1 n 0 1k
.op
.end
