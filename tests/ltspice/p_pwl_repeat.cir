* t
V1 a 0 0 PWL(0 0 0.001 1 {r} 0 {td} 0.0005)
R1 a 0 1k
.tran 9.999999999999999e-6 2.2500000000000004m
.end
