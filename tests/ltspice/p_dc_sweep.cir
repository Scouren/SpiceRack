* t
V1 in 0 0
R1 in out 2k
R2 out 0 1k
.dc v1 0 2 500m
.end
