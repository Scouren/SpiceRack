* t
V1 in 0 2
R1 in out 2k
R2 out 0 1k
B1 b 0 V=3*v(out)*v(out)
Rb b 0 1k
.op
.end
